* Extracted by KLayout with SG13G2 LVS runset on : 06/03/2026 17:07

.SUBCKT sar_logic A|Op A|clk A|En A|rst A|Om BN[0]|X B[0]|X VSS|gnd A|A1|X|net3
+ D|Y|_016_ A2|B|Y|_090_ B_N|Y|_089_ D|Y|_025_ B1|X|net1 D|Y|_001_ A|X|net4
+ A|B1|X|net29 A1|Y|_047_ A2|Y|_049_ A|X|net71 B|Y|_100_ A|Y|_088_ A|A2|X|net2
+ A|A1|B1|C|Q|counter\[3\] B_N|X|net83 A2|Y|_101_ A|B1|X|net30 A|Q|net5 VDD|vdd
+ BN[1]|X B[1]|X L_HI|RESET_B|net50 L_HI|RESET_B|net56 L_HI|RESET_B|net
+ A|Q|net6 A|Q|net13 CLK|X|clknet_2_0__leaf_clk CLK|X|clknet_2_2__leaf_clk
+ A|Y|_059_ B1|X|net84 A1|B|B1|C|X|net28 A|B1|X|net32 A|X|net86 A|X|net75
+ L_HI|RESET_B|net48 A1|A2|B_N|Y|_028_ L_HI|RESET_B|net44 B|C|Y|_074_
+ A2|B|C|Y|_070_ L_HI|RESET_B|net46 A1|X|net80 D|Y|_017_ B|X|net85 A|Y|_022_
+ A|A2|Q|counter\[0\] A|A1|A_N|B|C|Q|counter\[1\] B1|D|Y|_069_
+ A|B|B2|Q|counter\[2\] B|Y|_084_ A|X|net78 D|X|net79 D|Y|_002_ A|Y|_050_
+ A2|B|Y|_032_ A2|B|C|D|X|net27 B1|Y|_058_ A|Y|_024_ A2|Y|_029_ D|X|net87
+ B[2]|X BN[2]|X D|Y|_023_ A|B|B1|Y|_068_ A|B|C|X|_091_ A|A1|X|_071_ A|Y|_083_
+ A|Q|net14 A|Q|net7 A2|A_N|B|X|_027_ A|A2|Y|_034_ L_HI|RESET_B|net36
+ B|B2|C|Y|_079_ A_N|B1|Y|_072_ A1|A2|Y|_060_ L_HI|RESET_B|net57 A|B|Y|_073_
+ L_HI|RESET_B|net42 B1|Y|_051_ A|B|B1|Y|_078_ A|B|Y|_076_ A|B|D|X|_085_
+ A|Q|net8 B|C|D|Y|_097_ A2|B|C|Y|_092_ A2|X|_075_ B|X|net76 D|Y|_018_
+ A|A1|X|net33 C|D|Y|_030_ B|B_N|C|X|_077_ A2|Y|_033_ A|X|net70 D|Y|_015_
+ A|X|net69 A1|Y|_061_ A|A1|Y|_087_ A|Y|_082_ A|Q|net15 A|Y|_046_ C|D|Y|_026_
+ D|Y|_003_ BN[3]|X L_HI|RESET_B|net55 B[3]|X A2|A_N|B|Y|_035_ A1|A2|Y|_031_
+ L_HI|RESET_B|net54 L_HI|RESET_B|net40 A2|Y|_055_ A|B|X|_081_ D|Y|_000_
+ A2|Y|_095_ A|Q|net12 A|X|clknet_0_clk B|X|net74 A1|A2|B|Y|_093_ B1|X|net81
+ B1|D|X|_048_ C|Y|_096_ A|Q|net16 A1|X|net82 A1|A2|B_N|Y|_094_ A1|Y|_052_
+ B|X|net73 A2|D|Y|_038_ C|Y|_080_ A1|Y|_036_ A2|Y|_037_ A|B1|X|net31
+ A2|Y|_044_ D|Y|_019_ B1|D|X|_098_ A1|A2|Y|_099_ A2|Y|_057_ D|Y|_004_
+ A2|Y|_053_ B|C|Y|_086_ L_HI|RESET_B|net53 A|X|net67 L_HI|RESET_B|net38
+ B|Y|_040_ A1|A2|Y|_042_ L_HI|RESET_B|net49 A1|A2|Y|_039_ B|Y|_043_ BN[4]|X
+ D|Y|_007_ Y A1|Y|_056_ B|Y|_045_ A2|Y|_041_ A|CLK|X|clknet_2_3__leaf_clk
+ D|Y|_006_ A|Q|net18 B[4]|X A|Q|net9 A1|Y|_067_ A|CLK|X|clknet_2_1__leaf_clk
+ A|X|net77 A|Q|net11 B1|X|net60 A|X|net72 A|Q|net19 A|Q|net21 A|Q|net17
+ A|Q|net26 A1|Y|_066_ A|X|net68 D|Y|_020_ D|Y|_010_ A1|Y|_064_ D|Y|_011_
+ D|Y|_005_ D|Y|_012_ D|Y|_013_ L_HI|RESET_B|net47 A|X|net66 A|X|net65
+ D|Y|_009_ L_HI|RESET_B|net43 A1|Y|_054_ A|X|net63 D|Y|_021_
+ L_HI|RESET_B|net52 A1|Y|_063_ L_HI|RESET_B|net51 A1|Y|_062_ D|Y|_014_
+ L_HI|RESET_B|net58 L_HI|RESET_B|net45 L_HI|RESET_B|net34 L_HI|RESET_B|net41
+ L_HI|RESET_B|net39 L_HI|RESET_B|net35 A|Q|net20 A|Q|net10 A|Q|net22 A|Q|net23
+ A|Q|net24 A|Q|net25 B_N|X|net59 D|Y|_008_ A1|Y|_065_ A|X|net62
+ L_HI|RESET_B|net37 BN[5]|X BN[6]|X D[0]|X D[1]|X D[2]|X D[3]|X D[4]|X Y$1
+ D[5]|X D[6]|X D[7]|X B[6]|X B[5]|X A|X|net64 A|X|net61
M$1 VSS|gnd \$33 \$32 VSS|gnd sg13_lv_nmos L=0.13u W=0.795u AS=0.2043375p
+ AD=0.274275p PS=1.585u PD=2.28u
M$2 VSS|gnd \$34 \$34 VSS|gnd sg13_lv_nmos L=0.13u W=0.3u AS=0.2043375p
+ AD=0.111p PS=1.585u PD=1.34u
M$3 VSS|gnd \$40 \$39 VSS|gnd sg13_lv_nmos L=0.13u W=0.795u AS=0.2043375p
+ AD=0.274275p PS=1.585u PD=2.28u
M$4 VSS|gnd \$41 \$41 VSS|gnd sg13_lv_nmos L=0.13u W=0.3u AS=0.2043375p
+ AD=0.111p PS=1.585u PD=1.34u
M$5 BN[0]|X \$19 VSS|gnd VSS|gnd sg13_lv_nmos L=0.13u W=0.74u AS=0.2886p
+ AD=0.14875p PS=2.26u PD=1.16u
M$6 VSS|gnd A|Q|net5 \$19 VSS|gnd sg13_lv_nmos L=0.13u W=0.55u AS=0.14875p
+ AD=0.187p PS=1.16u PD=1.78u
M$7 VSS|gnd A|Op \$20 VSS|gnd sg13_lv_nmos L=0.13u W=0.55u AS=0.14875p
+ AD=0.187p PS=1.16u PD=1.78u
M$8 VSS|gnd \$20 A|A1|X|net3 VSS|gnd sg13_lv_nmos L=0.13u W=0.74u AS=0.14875p
+ AD=0.2886p PS=1.16u PD=2.26u
M$9 B1|X|net1 \$35 VSS|gnd VSS|gnd sg13_lv_nmos L=0.13u W=0.74u AS=0.2886p
+ AD=0.14875p PS=2.26u PD=1.16u
M$10 VSS|gnd A|En \$35 VSS|gnd sg13_lv_nmos L=0.13u W=0.55u AS=0.14875p
+ AD=0.187p PS=1.16u PD=1.78u
M$11 A|X|net4 \$42 VSS|gnd VSS|gnd sg13_lv_nmos L=0.13u W=0.74u AS=0.2886p
+ AD=0.14875p PS=2.26u PD=1.16u
M$12 VSS|gnd A|rst \$42 VSS|gnd sg13_lv_nmos L=0.13u W=0.55u AS=0.14875p
+ AD=0.187p PS=1.16u PD=1.78u
M$13 A|A2|X|net2 \$43 VSS|gnd VSS|gnd sg13_lv_nmos L=0.13u W=0.74u AS=0.2886p
+ AD=0.14875p PS=2.26u PD=1.16u
M$14 VSS|gnd A|Om \$43 VSS|gnd sg13_lv_nmos L=0.13u W=0.55u AS=0.14875p
+ AD=0.187p PS=1.16u PD=1.78u
M$15 VSS|gnd A|Q|net12 \$44 VSS|gnd sg13_lv_nmos L=0.13u W=0.55u AS=0.14875p
+ AD=0.187p PS=1.16u PD=1.78u
M$16 VSS|gnd \$44 B[0]|X VSS|gnd sg13_lv_nmos L=0.13u W=0.74u AS=0.14875p
+ AD=0.2886p PS=1.16u PD=2.26u
M$17 VSS|gnd VDD|vdd VSS|gnd VSS|gnd sg13_lv_nmos L=1u W=241.5u AS=65.541p
+ AD=65.541p PS=684.64u PD=684.64u
M$19 A1|Y|_047_ A|X|net71 \$47 VSS|gnd sg13_lv_nmos L=0.13u W=0.74u AS=0.2516p
+ AD=0.1406p PS=2.16u PD=1.12u
M$20 \$47 B|Y|_100_ VSS|gnd VSS|gnd sg13_lv_nmos L=0.13u W=0.74u AS=0.1406p
+ AD=0.2516p PS=1.12u PD=2.16u
M$21 VSS|gnd A|Y|_088_ A2|B|Y|_090_ VSS|gnd sg13_lv_nmos L=0.13u W=0.74u
+ AS=0.2516p AD=0.1406p PS=2.16u PD=1.12u
M$22 A2|B|Y|_090_ \$27 VSS|gnd VSS|gnd sg13_lv_nmos L=0.13u W=0.74u AS=0.1406p
+ AD=0.17255p PS=1.12u PD=1.25u
M$23 VSS|gnd B_N|Y|_089_ \$27 VSS|gnd sg13_lv_nmos L=0.13u W=0.55u AS=0.17255p
+ AD=0.187p PS=1.25u PD=1.78u
M$24 VSS|gnd A|B1|X|net32 D|Y|_025_ VSS|gnd sg13_lv_nmos L=0.13u W=0.74u
+ AS=0.2516p AD=0.1406p PS=2.16u PD=1.12u
M$25 D|Y|_025_ \$30 VSS|gnd VSS|gnd sg13_lv_nmos L=0.13u W=0.74u AS=0.1406p
+ AD=0.17255p PS=1.12u PD=1.25u
M$26 VSS|gnd B_N|X|net83 \$30 VSS|gnd sg13_lv_nmos L=0.13u W=0.55u AS=0.17255p
+ AD=0.187p PS=1.25u PD=1.78u
M$27 B_N|X|net83 \$36 VSS|gnd VSS|gnd sg13_lv_nmos L=0.13u W=0.74u AS=0.2516p
+ AD=0.1426p PS=2.16u PD=1.16u
M$28 VSS|gnd \$15 \$36 VSS|gnd sg13_lv_nmos L=0.5u W=0.42u AS=0.1426p
+ AD=0.1428p PS=1.16u PD=1.52u
M$29 \$15 \$16 VSS|gnd VSS|gnd sg13_lv_nmos L=0.5u W=0.42u AS=0.1428p
+ AD=0.0798p PS=1.52u PD=0.8u
M$30 VSS|gnd A|A1|B1|C|Q|counter\[3\] \$16 VSS|gnd sg13_lv_nmos L=0.13u W=0.42u
+ AS=0.0798p AD=0.1428p PS=0.8u PD=1.52u
M$93 VSS|gnd A|Q|net6 \$71 VSS|gnd sg13_lv_nmos L=0.13u W=0.55u AS=0.14875p
+ AD=0.187p PS=1.16u PD=1.78u
M$94 BN[1]|X \$71 VSS|gnd VSS|gnd sg13_lv_nmos L=0.13u W=0.74u AS=0.2886p
+ AD=0.14875p PS=2.26u PD=1.16u
M$123 \$72 \$76 \$73 VSS|gnd sg13_lv_nmos L=0.13u W=0.42u AS=0.1296p AD=0.0798p
+ PS=1.52u PD=0.8u
M$124 \$73 \$75 \$109 VSS|gnd sg13_lv_nmos L=0.13u W=0.42u AS=0.0798p
+ AD=0.2373p PS=0.8u PD=1.97u
M$125 VSS|gnd A|B1|X|net29 D|Y|_016_ VSS|gnd sg13_lv_nmos L=0.13u W=0.74u
+ AS=0.2516p AD=0.1406p PS=2.16u PD=1.12u
M$126 D|Y|_016_ A1|Y|_047_ \$48 VSS|gnd sg13_lv_nmos L=0.13u W=0.74u AS=0.1406p
+ AD=0.1406p PS=1.12u PD=1.12u
M$127 \$48 A2|Y|_049_ VSS|gnd VSS|gnd sg13_lv_nmos L=0.13u W=0.74u AS=0.1406p
+ AD=0.2516p PS=1.12u PD=2.16u
M$128 \$75 \$76 VSS|gnd VSS|gnd sg13_lv_nmos L=0.13u W=0.74u AS=0.2516p
+ AD=0.317325p PS=2.16u PD=1.805u
M$129 VSS|gnd CLK|X|clknet_2_0__leaf_clk \$76 VSS|gnd sg13_lv_nmos L=0.13u
+ W=0.74u AS=0.317325p AD=0.2516p PS=1.805u PD=2.16u
M$130 \$110 \$76 \$77 VSS|gnd sg13_lv_nmos L=0.13u W=0.42u AS=0.1428p
+ AD=0.12665p PS=1.52u PD=1.145u
M$131 \$77 \$75 \$74 VSS|gnd sg13_lv_nmos L=0.13u W=0.74u AS=0.12665p
+ AD=0.3473p PS=1.145u PD=2.71u
M$132 \$79 \$77 VSS|gnd VSS|gnd sg13_lv_nmos L=0.13u W=0.74u AS=0.2516p
+ AD=0.1406p PS=2.16u PD=1.12u
M$133 VSS|gnd \$79 A|Q|net6 VSS|gnd sg13_lv_nmos L=0.13u W=0.74u AS=0.1406p
+ AD=0.2516p PS=1.12u PD=2.16u
M$134 VSS|gnd \$81 \$80 VSS|gnd sg13_lv_nmos L=0.5u W=0.42u AS=0.1426p
+ AD=0.1428p PS=1.16u PD=1.52u
M$135 A|X|net71 \$80 VSS|gnd VSS|gnd sg13_lv_nmos L=0.13u W=0.74u AS=0.2516p
+ AD=0.1426p PS=2.16u PD=1.16u
M$136 VSS|gnd A|A2|X|net2 \$46 VSS|gnd sg13_lv_nmos L=0.13u W=0.74u AS=0.2516p
+ AD=0.1406p PS=2.16u PD=1.12u
M$137 \$46 A|A1|X|net33 B_N|Y|_089_ VSS|gnd sg13_lv_nmos L=0.13u W=0.74u
+ AS=0.1406p AD=0.1406p PS=1.12u PD=1.12u
M$138 B_N|Y|_089_ A|A1|B1|C|Q|counter\[3\] VSS|gnd VSS|gnd sg13_lv_nmos L=0.13u
+ W=0.74u AS=0.1406p AD=0.2516p PS=1.12u PD=2.16u
M$139 \$83 \$87 \$84 VSS|gnd sg13_lv_nmos L=0.13u W=0.42u AS=0.1296p AD=0.0798p
+ PS=1.52u PD=0.8u
M$140 \$84 \$86 \$111 VSS|gnd sg13_lv_nmos L=0.13u W=0.42u AS=0.0798p
+ AD=0.2373p PS=0.8u PD=1.97u
M$141 \$86 \$87 VSS|gnd VSS|gnd sg13_lv_nmos L=0.13u W=0.74u AS=0.2516p
+ AD=0.317325p PS=2.16u PD=1.805u
M$142 VSS|gnd CLK|X|clknet_2_2__leaf_clk \$87 VSS|gnd sg13_lv_nmos L=0.13u
+ W=0.74u AS=0.317325p AD=0.2516p PS=1.805u PD=2.16u
M$143 \$112 \$87 \$88 VSS|gnd sg13_lv_nmos L=0.13u W=0.42u AS=0.1428p
+ AD=0.12665p PS=1.52u PD=1.145u
M$144 \$88 \$86 \$85 VSS|gnd sg13_lv_nmos L=0.13u W=0.74u AS=0.12665p
+ AD=0.3473p PS=1.145u PD=2.71u
M$145 \$90 \$88 VSS|gnd VSS|gnd sg13_lv_nmos L=0.13u W=0.74u AS=0.2516p
+ AD=0.1406p PS=2.16u PD=1.12u
M$146 VSS|gnd \$90 A|A1|B1|C|Q|counter\[3\] VSS|gnd sg13_lv_nmos L=0.13u
+ W=0.74u AS=0.1406p AD=0.2516p PS=1.12u PD=2.16u
M$147 VSS|gnd A2|Y|_101_ \$45 VSS|gnd sg13_lv_nmos L=0.13u W=0.74u AS=0.2516p
+ AD=0.1406p PS=2.16u PD=1.12u
M$148 \$45 A1|A2|Y|_099_ D|Y|_001_ VSS|gnd sg13_lv_nmos L=0.13u W=0.74u
+ AS=0.1406p AD=0.1406p PS=1.12u PD=1.12u
M$149 D|Y|_001_ A|B1|X|net30 VSS|gnd VSS|gnd sg13_lv_nmos L=0.13u W=0.74u
+ AS=0.1406p AD=0.2516p PS=1.12u PD=2.16u
M$150 \$91 \$95 \$92 VSS|gnd sg13_lv_nmos L=0.13u W=0.42u AS=0.1296p AD=0.0798p
+ PS=1.52u PD=0.8u
M$151 \$92 \$94 \$113 VSS|gnd sg13_lv_nmos L=0.13u W=0.42u AS=0.0798p
+ AD=0.2373p PS=0.8u PD=1.97u
M$152 \$94 \$95 VSS|gnd VSS|gnd sg13_lv_nmos L=0.13u W=0.74u AS=0.2516p
+ AD=0.317325p PS=2.16u PD=1.805u
M$153 VSS|gnd CLK|X|clknet_2_2__leaf_clk \$95 VSS|gnd sg13_lv_nmos L=0.13u
+ W=0.74u AS=0.317325p AD=0.2516p PS=1.805u PD=2.16u
M$154 \$114 \$95 \$96 VSS|gnd sg13_lv_nmos L=0.13u W=0.42u AS=0.1428p
+ AD=0.12665p PS=1.52u PD=1.145u
M$155 \$96 \$94 \$93 VSS|gnd sg13_lv_nmos L=0.13u W=0.74u AS=0.12665p
+ AD=0.3473p PS=1.145u PD=2.71u
M$156 \$98 \$96 VSS|gnd VSS|gnd sg13_lv_nmos L=0.13u W=0.74u AS=0.2516p
+ AD=0.1406p PS=2.16u PD=1.12u
M$157 VSS|gnd \$98 A|Q|net13 VSS|gnd sg13_lv_nmos L=0.13u W=0.74u AS=0.1406p
+ AD=0.2516p PS=1.12u PD=2.16u
M$188 \$100 A|Q|net13 VSS|gnd VSS|gnd sg13_lv_nmos L=0.13u W=0.55u AS=0.187p
+ AD=0.14875p PS=1.78u PD=1.16u
M$189 VSS|gnd \$100 B[1]|X VSS|gnd sg13_lv_nmos L=0.13u W=0.74u AS=0.14875p
+ AD=0.2886p PS=1.16u PD=2.26u
M$221 VSS|gnd \$73 \$74 VSS|gnd sg13_lv_nmos L=0.13u W=0.74u AS=0.1626p
+ AD=0.2516p PS=1.415u PD=2.16u
M$222 \$72 D|Y|_016_ \$117 VSS|gnd sg13_lv_nmos L=0.13u W=0.42u AS=0.1428p
+ AD=0.0609p PS=1.52u PD=0.71u
M$223 VSS|gnd L_HI|RESET_B|net50 \$117 VSS|gnd sg13_lv_nmos L=0.13u W=0.42u
+ AS=0.1626p AD=0.0609p PS=1.415u PD=0.71u
M$224 VSS|gnd \$133 \$132 VSS|gnd sg13_lv_nmos L=0.13u W=0.795u AS=0.2043375p
+ AD=0.274275p PS=1.585u PD=2.28u
M$225 VSS|gnd \$134 \$134 VSS|gnd sg13_lv_nmos L=0.13u W=0.3u AS=0.2043375p
+ AD=0.111p PS=1.585u PD=1.34u
M$226 VSS|gnd L_HI|RESET_B|net50 \$118 VSS|gnd sg13_lv_nmos L=0.13u W=0.42u
+ AS=0.1701p AD=0.0378p PS=1.65u PD=0.6u
M$227 \$118 \$74 \$109 VSS|gnd sg13_lv_nmos L=0.13u W=0.42u AS=0.0378p
+ AD=0.1428p PS=0.6u PD=1.52u
M$228 VSS|gnd A|B1|X|net32 \$135 VSS|gnd sg13_lv_nmos L=0.13u W=0.55u
+ AS=0.14875p AD=0.187p PS=1.16u PD=1.78u
M$229 VSS|gnd \$135 A|B1|X|net29 VSS|gnd sg13_lv_nmos L=0.13u W=0.74u
+ AS=0.14875p AD=0.2886p PS=1.16u PD=2.26u
M$230 A1|B|B1|C|X|net28 \$137 VSS|gnd VSS|gnd sg13_lv_nmos L=0.13u W=0.74u
+ AS=0.2886p AD=0.14875p PS=2.26u PD=1.16u
M$231 VSS|gnd A|X|net86 \$137 VSS|gnd sg13_lv_nmos L=0.13u W=0.55u AS=0.14875p
+ AD=0.187p PS=1.16u PD=1.78u
M$234 \$110 \$78 VSS|gnd VSS|gnd sg13_lv_nmos L=0.13u W=0.42u AS=0.1428p
+ AD=0.0798p PS=1.52u PD=0.8u
M$235 VSS|gnd L_HI|RESET_B|net50 \$119 VSS|gnd sg13_lv_nmos L=0.13u W=0.42u
+ AS=0.0798p AD=0.0378p PS=0.8u PD=0.6u
M$236 \$119 \$77 \$78 VSS|gnd sg13_lv_nmos L=0.13u W=0.42u AS=0.0378p
+ AD=0.1428p PS=0.6u PD=1.52u
M$241 \$81 \$82 VSS|gnd VSS|gnd sg13_lv_nmos L=0.5u W=0.42u AS=0.1428p
+ AD=0.0798p PS=1.52u PD=0.8u
M$242 VSS|gnd A|Q|net6 \$82 VSS|gnd sg13_lv_nmos L=0.13u W=0.42u AS=0.0798p
+ AD=0.1428p PS=0.8u PD=1.52u
M$243 VSS|gnd \$84 \$85 VSS|gnd sg13_lv_nmos L=0.13u W=0.74u AS=0.1626p
+ AD=0.2516p PS=1.415u PD=2.16u
M$244 \$83 D|Y|_025_ \$121 VSS|gnd sg13_lv_nmos L=0.13u W=0.42u AS=0.1428p
+ AD=0.0609p PS=1.52u PD=0.71u
M$245 VSS|gnd L_HI|RESET_B|net56 \$121 VSS|gnd sg13_lv_nmos L=0.13u W=0.42u
+ AS=0.1626p AD=0.0609p PS=1.415u PD=0.71u
M$246 A|Y|_088_ B1|X|net1 \$128 VSS|gnd sg13_lv_nmos L=0.15u W=0.74u AS=0.2516p
+ AD=0.1406p PS=2.16u PD=1.12u
M$247 \$128 A|A2|X|net2 VSS|gnd VSS|gnd sg13_lv_nmos L=0.15u W=0.74u AS=0.1406p
+ AD=0.1406p PS=1.12u PD=1.12u
M$248 VSS|gnd A|A1|X|net33 \$128 VSS|gnd sg13_lv_nmos L=0.15u W=0.74u
+ AS=0.1406p AD=0.2516p PS=1.12u PD=2.16u
M$249 VSS|gnd L_HI|RESET_B|net56 \$122 VSS|gnd sg13_lv_nmos L=0.13u W=0.42u
+ AS=0.1701p AD=0.0378p PS=1.65u PD=0.6u
M$250 \$122 \$85 \$111 VSS|gnd sg13_lv_nmos L=0.13u W=0.42u AS=0.0378p
+ AD=0.1428p PS=0.6u PD=1.52u
M$255 \$112 \$89 VSS|gnd VSS|gnd sg13_lv_nmos L=0.13u W=0.42u AS=0.1428p
+ AD=0.0798p PS=1.52u PD=0.8u
M$256 VSS|gnd L_HI|RESET_B|net56 \$123 VSS|gnd sg13_lv_nmos L=0.13u W=0.42u
+ AS=0.0798p AD=0.0378p PS=0.8u PD=0.6u
M$257 \$123 \$88 \$89 VSS|gnd sg13_lv_nmos L=0.13u W=0.42u AS=0.0378p
+ AD=0.1428p PS=0.6u PD=1.52u
M$259 VSS|gnd B|Y|_100_ \$146 VSS|gnd sg13_lv_nmos L=0.13u W=0.74u AS=0.2516p
+ AD=0.1406p PS=2.16u PD=1.12u
M$260 \$146 A|X|net75 A2|Y|_101_ VSS|gnd sg13_lv_nmos L=0.13u W=0.74u
+ AS=0.1406p AD=0.2516p PS=1.12u PD=2.16u
M$263 VSS|gnd \$92 \$93 VSS|gnd sg13_lv_nmos L=0.13u W=0.74u AS=0.1626p
+ AD=0.2516p PS=1.415u PD=2.16u
M$264 \$91 D|Y|_001_ \$124 VSS|gnd sg13_lv_nmos L=0.13u W=0.42u AS=0.1428p
+ AD=0.0609p PS=1.52u PD=0.71u
M$265 VSS|gnd L_HI|RESET_B|net \$124 VSS|gnd sg13_lv_nmos L=0.13u W=0.42u
+ AS=0.1626p AD=0.0609p PS=1.415u PD=0.71u
M$266 VSS|gnd L_HI|RESET_B|net \$125 VSS|gnd sg13_lv_nmos L=0.13u W=0.42u
+ AS=0.1701p AD=0.0378p PS=1.65u PD=0.6u
M$267 \$125 \$93 \$113 VSS|gnd sg13_lv_nmos L=0.13u W=0.42u AS=0.0378p
+ AD=0.1428p PS=0.6u PD=1.52u
M$269 A|X|net75 \$140 VSS|gnd VSS|gnd sg13_lv_nmos L=0.13u W=0.74u AS=0.2516p
+ AD=0.1426p PS=2.16u PD=1.16u
M$270 VSS|gnd \$141 \$140 VSS|gnd sg13_lv_nmos L=0.5u W=0.42u AS=0.1426p
+ AD=0.1428p PS=1.16u PD=1.52u
M$271 \$141 \$129 VSS|gnd VSS|gnd sg13_lv_nmos L=0.5u W=0.42u AS=0.1428p
+ AD=0.0798p PS=1.52u PD=0.8u
M$272 VSS|gnd A|Q|net13 \$129 VSS|gnd sg13_lv_nmos L=0.13u W=0.42u AS=0.0798p
+ AD=0.1428p PS=0.8u PD=1.52u
M$273 \$114 \$97 VSS|gnd VSS|gnd sg13_lv_nmos L=0.13u W=0.42u AS=0.1428p
+ AD=0.0798p PS=1.52u PD=0.8u
M$274 VSS|gnd L_HI|RESET_B|net \$126 VSS|gnd sg13_lv_nmos L=0.13u W=0.42u
+ AS=0.0798p AD=0.0378p PS=0.8u PD=0.6u
M$275 \$126 \$96 \$97 VSS|gnd sg13_lv_nmos L=0.13u W=0.42u AS=0.0378p
+ AD=0.1428p PS=0.6u PD=1.52u
M$276 VSS|gnd \$143 \$142 VSS|gnd sg13_lv_nmos L=0.13u W=0.795u AS=0.2043375p
+ AD=0.274275p PS=1.585u PD=2.28u
M$277 VSS|gnd \$144 \$144 VSS|gnd sg13_lv_nmos L=0.13u W=0.3u AS=0.2043375p
+ AD=0.111p PS=1.585u PD=1.34u
M$321 \$205 \$205 VSS|gnd VSS|gnd sg13_lv_nmos L=0.13u W=0.3u AS=0.111p
+ AD=0.2043375p PS=1.34u PD=1.585u
M$322 VSS|gnd \$158 \$198 VSS|gnd sg13_lv_nmos L=0.13u W=0.795u AS=0.2043375p
+ AD=0.274275p PS=1.585u PD=2.28u
M$323 \$162 \$161 VSS|gnd VSS|gnd sg13_lv_nmos L=0.5u W=0.42u AS=0.1428p
+ AD=0.1426p PS=1.52u PD=1.16u
M$324 VSS|gnd \$162 A1|X|net80 VSS|gnd sg13_lv_nmos L=0.13u W=0.74u AS=0.1426p
+ AD=0.2516p PS=1.16u PD=2.16u
M$325 VSS|gnd A1|A2|B_N|Y|_028_ \$165 VSS|gnd sg13_lv_nmos L=0.13u W=0.55u
+ AS=0.17255p AD=0.187p PS=1.25u PD=1.78u
M$326 VSS|gnd A|Y|_050_ D|Y|_017_ VSS|gnd sg13_lv_nmos L=0.13u W=0.74u
+ AS=0.2516p AD=0.1406p PS=2.16u PD=1.12u
M$327 D|Y|_017_ \$165 VSS|gnd VSS|gnd sg13_lv_nmos L=0.13u W=0.74u AS=0.1406p
+ AD=0.17255p PS=1.12u PD=1.25u
M$332 A|A2|Y|_034_ A|B|B1|Y|_068_ \$222 VSS|gnd sg13_lv_nmos L=0.13u W=0.74u
+ AS=0.2516p AD=0.1406p PS=2.16u PD=1.12u
M$333 \$222 A2|B|Y|_032_ VSS|gnd VSS|gnd sg13_lv_nmos L=0.13u W=0.74u
+ AS=0.1406p AD=0.2516p PS=1.12u PD=2.16u
M$334 VSS|gnd \$168 \$167 VSS|gnd sg13_lv_nmos L=0.5u W=0.42u AS=0.1426p
+ AD=0.1428p PS=1.16u PD=1.52u
M$335 B|X|net85 \$167 VSS|gnd VSS|gnd sg13_lv_nmos L=0.13u W=0.74u AS=0.2516p
+ AD=0.1426p PS=2.16u PD=1.16u
M$336 VSS|gnd A2|B|C|D|X|net27 \$223 VSS|gnd sg13_lv_nmos L=0.13u W=0.74u
+ AS=0.2516p AD=0.1406p PS=2.16u PD=1.12u
M$337 \$223 A1|B|B1|C|X|net28 A|Y|_022_ VSS|gnd sg13_lv_nmos L=0.13u W=0.74u
+ AS=0.1406p AD=0.1406p PS=1.12u PD=1.12u
M$338 A|Y|_022_ B1|Y|_058_ VSS|gnd VSS|gnd sg13_lv_nmos L=0.13u W=0.74u
+ AS=0.1406p AD=0.2516p PS=1.12u PD=2.16u
M$339 VSS|gnd B1|X|net84 A|Y|_059_ VSS|gnd sg13_lv_nmos L=0.13u W=0.74u
+ AS=0.2516p AD=0.1406p PS=2.16u PD=1.12u
M$340 A|Y|_059_ A1|B|B1|C|X|net28 \$145 VSS|gnd sg13_lv_nmos L=0.13u W=0.74u
+ AS=0.1406p AD=0.1406p PS=1.12u PD=1.12u
M$341 \$145 A2|B|Y|_090_ VSS|gnd VSS|gnd sg13_lv_nmos L=0.13u W=0.74u
+ AS=0.1406p AD=0.2516p PS=1.12u PD=2.16u
M$342 \$172 \$176 \$174 VSS|gnd sg13_lv_nmos L=0.13u W=0.42u AS=0.1296p
+ AD=0.0798p PS=1.52u PD=0.8u
M$343 \$174 \$175 \$207 VSS|gnd sg13_lv_nmos L=0.13u W=0.42u AS=0.0798p
+ AD=0.2373p PS=0.8u PD=1.97u
M$344 \$175 \$176 VSS|gnd VSS|gnd sg13_lv_nmos L=0.13u W=0.74u AS=0.2516p
+ AD=0.317325p PS=2.16u PD=1.805u
M$345 VSS|gnd CLK|X|clknet_2_0__leaf_clk \$176 VSS|gnd sg13_lv_nmos L=0.13u
+ W=0.74u AS=0.317325p AD=0.2516p PS=1.805u PD=2.16u
M$346 \$208 \$176 \$177 VSS|gnd sg13_lv_nmos L=0.13u W=0.42u AS=0.1428p
+ AD=0.12665p PS=1.52u PD=1.145u
M$347 \$177 \$175 \$173 VSS|gnd sg13_lv_nmos L=0.13u W=0.74u AS=0.12665p
+ AD=0.3473p PS=1.145u PD=2.71u
M$348 \$179 \$177 VSS|gnd VSS|gnd sg13_lv_nmos L=0.13u W=0.74u AS=0.2516p
+ AD=0.1406p PS=2.16u PD=1.12u
M$349 VSS|gnd \$179 A|A2|Q|counter\[0\] VSS|gnd sg13_lv_nmos L=0.13u W=0.74u
+ AS=0.1406p AD=0.2516p PS=1.12u PD=2.16u
M$354 VSS|gnd A|A1|A_N|B|C|Q|counter\[1\] \$227 VSS|gnd sg13_lv_nmos L=0.13u
+ W=0.74u AS=0.2516p AD=0.1406p PS=2.16u PD=1.12u
M$355 \$227 A|A1|B1|C|Q|counter\[3\] B1|D|Y|_069_ VSS|gnd sg13_lv_nmos L=0.13u
+ W=0.74u AS=0.1406p AD=0.2516p PS=1.12u PD=2.16u
M$356 B|C|Y|_074_ A|A1|B1|C|Q|counter\[3\] \$229 VSS|gnd sg13_lv_nmos L=0.13u
+ W=0.74u AS=0.2516p AD=0.1406p PS=2.16u PD=1.12u
M$357 \$229 A1|B|B1|C|X|net28 \$228 VSS|gnd sg13_lv_nmos L=0.13u W=0.74u
+ AS=0.1406p AD=0.1406p PS=1.12u PD=1.12u
M$358 \$228 A2|B|C|Y|_070_ VSS|gnd VSS|gnd sg13_lv_nmos L=0.13u W=0.74u
+ AS=0.1406p AD=0.2886p PS=1.12u PD=2.26u
M$359 VSS|gnd A|A2|Q|counter\[0\] \$230 VSS|gnd sg13_lv_nmos L=0.13u W=0.74u
+ AS=0.2516p AD=0.0962p PS=2.16u PD=1u
M$360 \$230 A|A1|A_N|B|C|Q|counter\[1\] B|Y|_084_ VSS|gnd sg13_lv_nmos L=0.13u
+ W=0.74u AS=0.0962p AD=0.2664p PS=1u PD=1.46u
M$361 B|Y|_084_ A|B|B2|Q|counter\[2\] \$231 VSS|gnd sg13_lv_nmos L=0.13u
+ W=0.74u AS=0.2664p AD=0.13875p PS=1.46u PD=1.115u
M$362 \$231 B1|D|Y|_069_ VSS|gnd VSS|gnd sg13_lv_nmos L=0.13u W=0.74u
+ AS=0.13875p AD=0.2553p PS=1.115u PD=2.17u
M$363 A2|B|C|Y|_070_ A|A1|B1|C|Q|counter\[3\] \$233 VSS|gnd sg13_lv_nmos
+ L=0.13u W=0.74u AS=0.2516p AD=0.1406p PS=2.16u PD=1.12u
M$364 \$233 A|B|B2|Q|counter\[2\] \$232 VSS|gnd sg13_lv_nmos L=0.13u W=0.74u
+ AS=0.1406p AD=0.1406p PS=1.12u PD=1.12u
M$365 \$232 A|A1|A_N|B|C|Q|counter\[1\] VSS|gnd VSS|gnd sg13_lv_nmos L=0.13u
+ W=0.74u AS=0.1406p AD=0.2886p PS=1.12u PD=2.26u
M$370 VSS|gnd \$188 \$187 VSS|gnd sg13_lv_nmos L=0.5u W=0.42u AS=0.1426p
+ AD=0.1428p PS=1.16u PD=1.52u
M$371 D|X|net79 \$187 VSS|gnd VSS|gnd sg13_lv_nmos L=0.13u W=0.74u AS=0.2516p
+ AD=0.1426p PS=2.16u PD=1.16u
M$372 VSS|gnd \$191 \$190 VSS|gnd sg13_lv_nmos L=0.5u W=0.42u AS=0.1426p
+ AD=0.1428p PS=1.16u PD=1.52u
M$373 A|X|net78 \$190 VSS|gnd VSS|gnd sg13_lv_nmos L=0.13u W=0.74u AS=0.2516p
+ AD=0.1426p PS=2.16u PD=1.16u
M$374 VSS|gnd A2|Y|_029_ \$234 VSS|gnd sg13_lv_nmos L=0.13u W=0.74u AS=0.2516p
+ AD=0.1406p PS=2.16u PD=1.12u
M$375 \$234 A1|A2|B_N|Y|_028_ D|Y|_002_ VSS|gnd sg13_lv_nmos L=0.13u W=0.74u
+ AS=0.1406p AD=0.1406p PS=1.12u PD=1.12u
M$376 D|Y|_002_ A|B1|X|net30 VSS|gnd VSS|gnd sg13_lv_nmos L=0.13u W=0.74u
+ AS=0.1406p AD=0.2516p PS=1.12u PD=2.16u
M$403 BN[2]|X \$261 VSS|gnd VSS|gnd sg13_lv_nmos L=0.13u W=0.74u AS=0.2886p
+ AD=0.14875p PS=2.26u PD=1.16u
M$404 VSS|gnd A|Q|net7 \$261 VSS|gnd sg13_lv_nmos L=0.13u W=0.55u AS=0.14875p
+ AD=0.187p PS=1.16u PD=1.78u
M$405 A|Q|net7 \$243 VSS|gnd VSS|gnd sg13_lv_nmos L=0.13u W=0.74u AS=0.2516p
+ AD=0.1406p PS=2.16u PD=1.12u
M$406 VSS|gnd \$262 \$243 VSS|gnd sg13_lv_nmos L=0.13u W=0.74u AS=0.1406p
+ AD=0.2516p PS=1.12u PD=2.16u
M$407 \$244 \$262 \$296 VSS|gnd sg13_lv_nmos L=0.13u W=0.42u AS=0.1428p
+ AD=0.0378p PS=1.52u PD=0.6u
M$408 \$296 L_HI|RESET_B|net46 VSS|gnd VSS|gnd sg13_lv_nmos L=0.13u W=0.42u
+ AS=0.0378p AD=0.0798p PS=0.6u PD=0.8u
M$409 VSS|gnd \$244 \$245 VSS|gnd sg13_lv_nmos L=0.13u W=0.42u AS=0.0798p
+ AD=0.1428p PS=0.8u PD=1.52u
M$410 \$235 \$263 \$262 VSS|gnd sg13_lv_nmos L=0.13u W=0.74u AS=0.3473p
+ AD=0.12665p PS=2.71u PD=1.145u
M$411 \$262 \$320 \$245 VSS|gnd sg13_lv_nmos L=0.13u W=0.42u AS=0.12665p
+ AD=0.1428p PS=1.145u PD=1.52u
M$413 \$160 A|Q|net7 VSS|gnd VSS|gnd sg13_lv_nmos L=0.13u W=0.42u AS=0.1428p
+ AD=0.0798p PS=1.52u PD=0.8u
M$414 VSS|gnd \$160 \$161 VSS|gnd sg13_lv_nmos L=0.5u W=0.42u AS=0.0798p
+ AD=0.1428p PS=0.8u PD=1.52u
M$415 \$264 \$235 \$298 VSS|gnd sg13_lv_nmos L=0.13u W=0.42u AS=0.1428p
+ AD=0.0378p PS=1.52u PD=0.6u
M$416 \$298 L_HI|RESET_B|net46 VSS|gnd VSS|gnd sg13_lv_nmos L=0.13u W=0.42u
+ AS=0.0378p AD=0.1701p PS=0.6u PD=1.65u
M$417 VSS|gnd L_HI|RESET_B|net46 \$300 VSS|gnd sg13_lv_nmos L=0.13u W=0.42u
+ AS=0.1626p AD=0.0609p PS=1.415u PD=0.71u
M$418 \$300 D|Y|_017_ \$265 VSS|gnd sg13_lv_nmos L=0.13u W=0.42u AS=0.0609p
+ AD=0.1428p PS=0.71u PD=1.52u
M$419 VSS|gnd \$266 \$235 VSS|gnd sg13_lv_nmos L=0.13u W=0.74u AS=0.1626p
+ AD=0.2516p PS=1.415u PD=2.16u
M$420 \$246 A1|X|net80 VSS|gnd VSS|gnd sg13_lv_nmos L=0.15u W=0.74u AS=0.2516p
+ AD=0.1406p PS=2.16u PD=1.12u
M$421 VSS|gnd A2|A_N|B|X|_027_ \$246 VSS|gnd sg13_lv_nmos L=0.15u W=0.74u
+ AS=0.1406p AD=0.1406p PS=1.12u PD=1.12u
M$422 \$246 A|B|B1|Y|_068_ A|Y|_050_ VSS|gnd sg13_lv_nmos L=0.15u W=0.74u
+ AS=0.1406p AD=0.2516p PS=1.12u PD=2.16u
M$424 VSS|gnd A|A2|Y|_034_ D|Y|_023_ VSS|gnd sg13_lv_nmos L=0.13u W=0.74u
+ AS=0.2516p AD=0.1406p PS=2.16u PD=1.12u
M$425 D|Y|_023_ B|X|net85 VSS|gnd VSS|gnd sg13_lv_nmos L=0.13u W=0.74u
+ AS=0.1406p AD=0.2516p PS=1.12u PD=2.16u
M$426 \$248 D|Y|_023_ \$303 VSS|gnd sg13_lv_nmos L=0.13u W=0.42u AS=0.1428p
+ AD=0.0609p PS=1.52u PD=0.71u
M$427 \$303 L_HI|RESET_B|net36 VSS|gnd VSS|gnd sg13_lv_nmos L=0.13u W=0.42u
+ AS=0.0609p AD=0.1626p PS=0.71u PD=1.415u
M$428 VSS|gnd \$323 \$236 VSS|gnd sg13_lv_nmos L=0.13u W=0.74u AS=0.1626p
+ AD=0.2516p PS=1.415u PD=2.16u
M$430 VSS|gnd L_HI|RESET_B|net36 \$304 VSS|gnd sg13_lv_nmos L=0.13u W=0.42u
+ AS=0.1701p AD=0.0378p PS=1.65u PD=0.6u
M$431 \$304 \$236 \$268 VSS|gnd sg13_lv_nmos L=0.13u W=0.42u AS=0.0378p
+ AD=0.1428p PS=0.6u PD=1.52u
M$432 \$270 \$237 \$249 VSS|gnd sg13_lv_nmos L=0.13u W=0.42u AS=0.12665p
+ AD=0.1428p PS=1.145u PD=1.52u
M$433 \$236 \$269 \$270 VSS|gnd sg13_lv_nmos L=0.13u W=0.74u AS=0.3473p
+ AD=0.12665p PS=2.71u PD=1.145u
M$434 \$168 \$169 VSS|gnd VSS|gnd sg13_lv_nmos L=0.5u W=0.42u AS=0.1428p
+ AD=0.0798p PS=1.52u PD=0.8u
M$435 VSS|gnd A|Y|_059_ \$169 VSS|gnd sg13_lv_nmos L=0.13u W=0.42u AS=0.0798p
+ AD=0.1428p PS=0.8u PD=1.52u
M$436 \$249 \$250 VSS|gnd VSS|gnd sg13_lv_nmos L=0.13u W=0.42u AS=0.1428p
+ AD=0.0798p PS=1.52u PD=0.8u
M$437 VSS|gnd L_HI|RESET_B|net36 \$307 VSS|gnd sg13_lv_nmos L=0.13u W=0.42u
+ AS=0.0798p AD=0.0378p PS=0.8u PD=0.6u
M$438 \$307 \$270 \$250 VSS|gnd sg13_lv_nmos L=0.13u W=0.42u AS=0.0378p
+ AD=0.1428p PS=0.6u PD=1.52u
M$439 \$251 \$270 VSS|gnd VSS|gnd sg13_lv_nmos L=0.13u W=0.74u AS=0.2516p
+ AD=0.1406p PS=2.16u PD=1.12u
M$440 VSS|gnd \$251 A|A1|A_N|B|C|Q|counter\[1\] VSS|gnd sg13_lv_nmos L=0.13u
+ W=0.74u AS=0.1406p AD=0.2516p PS=1.12u PD=2.16u
M$441 VSS|gnd \$174 \$173 VSS|gnd sg13_lv_nmos L=0.13u W=0.74u AS=0.1626p
+ AD=0.2516p PS=1.415u PD=2.16u
M$442 \$172 D|X|net87 \$224 VSS|gnd sg13_lv_nmos L=0.13u W=0.42u AS=0.1428p
+ AD=0.0609p PS=1.52u PD=0.71u
M$443 VSS|gnd L_HI|RESET_B|net44 \$224 VSS|gnd sg13_lv_nmos L=0.13u W=0.42u
+ AS=0.1626p AD=0.0609p PS=1.415u PD=0.71u
M$444 D|X|net87 \$271 VSS|gnd VSS|gnd sg13_lv_nmos L=0.13u W=0.74u AS=0.2516p
+ AD=0.1426p PS=2.16u PD=1.16u
M$445 VSS|gnd \$272 \$271 VSS|gnd sg13_lv_nmos L=0.5u W=0.42u AS=0.1426p
+ AD=0.1428p PS=1.16u PD=1.52u
M$446 VSS|gnd L_HI|RESET_B|net44 \$225 VSS|gnd sg13_lv_nmos L=0.13u W=0.42u
+ AS=0.1701p AD=0.0378p PS=1.65u PD=0.6u
M$447 \$225 \$173 \$207 VSS|gnd sg13_lv_nmos L=0.13u W=0.42u AS=0.0378p
+ AD=0.1428p PS=0.6u PD=1.52u
M$448 \$272 \$273 VSS|gnd VSS|gnd sg13_lv_nmos L=0.5u W=0.42u AS=0.1428p
+ AD=0.0798p PS=1.52u PD=0.8u
M$449 VSS|gnd A|Y|_022_ \$273 VSS|gnd sg13_lv_nmos L=0.13u W=0.42u AS=0.0798p
+ AD=0.1428p PS=0.8u PD=1.52u
M$450 B1|Y|_058_ A|B|B1|Y|_068_ \$252 VSS|gnd sg13_lv_nmos L=0.15u W=0.74u
+ AS=0.2516p AD=0.1406p PS=2.16u PD=1.12u
M$451 \$252 A2|B|Y|_090_ VSS|gnd VSS|gnd sg13_lv_nmos L=0.15u W=0.74u
+ AS=0.1406p AD=0.1406p PS=1.12u PD=1.12u
M$452 VSS|gnd A1|B|B1|C|X|net28 \$252 VSS|gnd sg13_lv_nmos L=0.15u W=0.74u
+ AS=0.1406p AD=0.2516p PS=1.12u PD=2.16u
M$453 \$208 \$178 VSS|gnd VSS|gnd sg13_lv_nmos L=0.13u W=0.42u AS=0.1428p
+ AD=0.0798p PS=1.52u PD=0.8u
M$454 VSS|gnd L_HI|RESET_B|net44 \$226 VSS|gnd sg13_lv_nmos L=0.13u W=0.42u
+ AS=0.0798p AD=0.0378p PS=0.8u PD=0.6u
M$455 \$226 \$177 \$178 VSS|gnd sg13_lv_nmos L=0.13u W=0.42u AS=0.0378p
+ AD=0.1428p PS=0.6u PD=1.52u
M$456 A|X|net86 \$276 VSS|gnd VSS|gnd sg13_lv_nmos L=0.13u W=0.74u AS=0.2516p
+ AD=0.1426p PS=2.16u PD=1.16u
M$457 VSS|gnd \$277 \$276 VSS|gnd sg13_lv_nmos L=0.5u W=0.42u AS=0.1426p
+ AD=0.1428p PS=1.16u PD=1.52u
M$458 \$277 \$278 VSS|gnd VSS|gnd sg13_lv_nmos L=0.5u W=0.42u AS=0.1428p
+ AD=0.0798p PS=1.52u PD=0.8u
M$459 VSS|gnd A|A2|Q|counter\[0\] \$278 VSS|gnd sg13_lv_nmos L=0.13u W=0.42u
+ AS=0.0798p AD=0.1428p PS=0.8u PD=1.52u
M$460 VSS|gnd \$280 \$279 VSS|gnd sg13_lv_nmos L=0.13u W=0.795u AS=0.2043375p
+ AD=0.274275p PS=1.585u PD=2.28u
M$461 VSS|gnd \$281 \$281 VSS|gnd sg13_lv_nmos L=0.13u W=0.3u AS=0.2043375p
+ AD=0.111p PS=1.585u PD=1.34u
M$462 VSS|gnd A|A1|A_N|B|C|Q|counter\[1\] \$283 VSS|gnd sg13_lv_nmos L=0.13u
+ W=0.55u AS=0.18575p AD=0.187p PS=1.26u PD=1.78u
M$463 VSS|gnd A|A1|B1|C|Q|counter\[3\] \$318 VSS|gnd sg13_lv_nmos L=0.13u
+ W=0.74u AS=0.18575p AD=0.1406p PS=1.26u PD=1.12u
M$464 \$318 A1|B|B1|C|X|net28 \$317 VSS|gnd sg13_lv_nmos L=0.13u W=0.74u
+ AS=0.1406p AD=0.1406p PS=1.12u PD=1.12u
M$465 \$317 \$283 B|B2|C|Y|_079_ VSS|gnd sg13_lv_nmos L=0.13u W=0.74u
+ AS=0.1406p AD=0.3404p PS=1.12u PD=2.4u
M$466 VSS|gnd B1|D|Y|_069_ \$314 VSS|gnd sg13_lv_nmos L=0.13u W=0.74u
+ AS=0.2516p AD=0.1406p PS=2.16u PD=1.12u
M$467 \$314 A1|B|B1|C|X|net28 \$313 VSS|gnd sg13_lv_nmos L=0.13u W=0.74u
+ AS=0.1406p AD=0.1406p PS=1.12u PD=1.12u
M$468 \$313 A|A1|A_N|B|C|Q|counter\[1\] \$312 VSS|gnd sg13_lv_nmos L=0.13u
+ W=0.74u AS=0.1406p AD=0.1406p PS=1.12u PD=1.12u
M$469 \$312 A|B|B2|Q|counter\[2\] A|B|Y|_073_ VSS|gnd sg13_lv_nmos L=0.13u
+ W=0.74u AS=0.1406p AD=0.2516p PS=1.12u PD=2.16u
M$470 A2|B|Y|_032_ \$286 \$310 VSS|gnd sg13_lv_nmos L=0.13u W=0.74u AS=0.333p
+ AD=0.1406p PS=2.38u PD=1.12u
M$471 \$310 A|B|C|X|_091_ VSS|gnd VSS|gnd sg13_lv_nmos L=0.13u W=0.74u
+ AS=0.1406p AD=0.14505p PS=1.12u PD=1.15u
M$472 VSS|gnd A_N|B1|Y|_072_ \$286 VSS|gnd sg13_lv_nmos L=0.13u W=0.55u
+ AS=0.14505p AD=0.187p PS=1.15u PD=1.78u
M$473 A1|A2|Y|_060_ A|X|net78 VSS|gnd VSS|gnd sg13_lv_nmos L=0.13u W=0.74u
+ AS=0.2516p AD=0.2516p PS=2.16u PD=2.16u
M$475 \$253 D|X|net79 \$306 VSS|gnd sg13_lv_nmos L=0.13u W=0.42u AS=0.1428p
+ AD=0.0609p PS=1.52u PD=0.71u
M$476 \$306 L_HI|RESET_B|net48 VSS|gnd VSS|gnd sg13_lv_nmos L=0.13u W=0.42u
+ AS=0.0609p AD=0.1626p PS=0.71u PD=1.415u
M$477 VSS|gnd \$331 \$238 VSS|gnd sg13_lv_nmos L=0.13u W=0.74u AS=0.1626p
+ AD=0.2516p PS=1.415u PD=2.16u
M$478 VSS|gnd L_HI|RESET_B|net48 \$305 VSS|gnd sg13_lv_nmos L=0.13u W=0.42u
+ AS=0.1701p AD=0.0378p PS=1.65u PD=0.6u
M$479 \$305 \$238 \$288 VSS|gnd sg13_lv_nmos L=0.13u W=0.42u AS=0.0378p
+ AD=0.1428p PS=0.6u PD=1.52u
M$480 \$188 \$189 VSS|gnd VSS|gnd sg13_lv_nmos L=0.5u W=0.42u AS=0.1428p
+ AD=0.0798p PS=1.52u PD=0.8u
M$481 VSS|gnd A|Y|_024_ \$189 VSS|gnd sg13_lv_nmos L=0.13u W=0.42u AS=0.0798p
+ AD=0.1428p PS=0.8u PD=1.52u
M$482 \$191 \$192 VSS|gnd VSS|gnd sg13_lv_nmos L=0.5u W=0.42u AS=0.1428p
+ AD=0.0798p PS=1.52u PD=0.8u
M$483 VSS|gnd A|B|B2|Q|counter\[2\] \$192 VSS|gnd sg13_lv_nmos L=0.13u W=0.42u
+ AS=0.0798p AD=0.1428p PS=0.8u PD=1.52u
M$484 \$290 \$239 \$254 VSS|gnd sg13_lv_nmos L=0.13u W=0.42u AS=0.12665p
+ AD=0.1428p PS=1.145u PD=1.52u
M$485 \$238 \$289 \$290 VSS|gnd sg13_lv_nmos L=0.13u W=0.74u AS=0.3473p
+ AD=0.12665p PS=2.71u PD=1.145u
M$486 \$254 \$255 VSS|gnd VSS|gnd sg13_lv_nmos L=0.13u W=0.42u AS=0.1428p
+ AD=0.0798p PS=1.52u PD=0.8u
M$487 VSS|gnd L_HI|RESET_B|net48 \$302 VSS|gnd sg13_lv_nmos L=0.13u W=0.42u
+ AS=0.0798p AD=0.0378p PS=0.8u PD=0.6u
M$488 \$302 \$290 \$255 VSS|gnd sg13_lv_nmos L=0.13u W=0.42u AS=0.0378p
+ AD=0.1428p PS=0.6u PD=1.52u
M$489 \$256 \$290 VSS|gnd VSS|gnd sg13_lv_nmos L=0.13u W=0.74u AS=0.2516p
+ AD=0.1406p PS=2.16u PD=1.12u
M$490 VSS|gnd \$256 A|B|B2|Q|counter\[2\] VSS|gnd sg13_lv_nmos L=0.13u W=0.74u
+ AS=0.1406p AD=0.2516p PS=1.12u PD=2.16u
M$491 \$257 D|Y|_002_ \$301 VSS|gnd sg13_lv_nmos L=0.13u W=0.42u AS=0.1428p
+ AD=0.0609p PS=1.52u PD=0.71u
M$492 \$301 L_HI|RESET_B|net57 VSS|gnd VSS|gnd sg13_lv_nmos L=0.13u W=0.42u
+ AS=0.0609p AD=0.1626p PS=0.71u PD=1.415u
M$493 VSS|gnd \$332 \$240 VSS|gnd sg13_lv_nmos L=0.13u W=0.74u AS=0.1626p
+ AD=0.2516p PS=1.415u PD=2.16u
M$494 VSS|gnd L_HI|RESET_B|net57 \$299 VSS|gnd sg13_lv_nmos L=0.13u W=0.42u
+ AS=0.1701p AD=0.0378p PS=1.65u PD=0.6u
M$495 \$299 \$240 \$291 VSS|gnd sg13_lv_nmos L=0.13u W=0.42u AS=0.0378p
+ AD=0.1428p PS=0.6u PD=1.52u
M$496 \$293 \$241 \$258 VSS|gnd sg13_lv_nmos L=0.13u W=0.42u AS=0.12665p
+ AD=0.1428p PS=1.145u PD=1.52u
M$497 \$240 \$292 \$293 VSS|gnd sg13_lv_nmos L=0.13u W=0.74u AS=0.3473p
+ AD=0.12665p PS=2.71u PD=1.145u
M$498 \$258 \$259 VSS|gnd VSS|gnd sg13_lv_nmos L=0.13u W=0.42u AS=0.1428p
+ AD=0.0798p PS=1.52u PD=0.8u
M$499 VSS|gnd L_HI|RESET_B|net57 \$297 VSS|gnd sg13_lv_nmos L=0.13u W=0.42u
+ AS=0.0798p AD=0.0378p PS=0.8u PD=0.6u
M$500 \$297 \$293 \$259 VSS|gnd sg13_lv_nmos L=0.13u W=0.42u AS=0.0378p
+ AD=0.1428p PS=0.6u PD=1.52u
M$501 \$260 \$293 VSS|gnd VSS|gnd sg13_lv_nmos L=0.13u W=0.74u AS=0.2516p
+ AD=0.1406p PS=2.16u PD=1.12u
M$502 VSS|gnd \$260 A|Q|net14 VSS|gnd sg13_lv_nmos L=0.13u W=0.74u AS=0.1406p
+ AD=0.2516p PS=1.12u PD=2.16u
M$504 VSS|gnd A|Q|net14 \$295 VSS|gnd sg13_lv_nmos L=0.13u W=0.55u AS=0.14875p
+ AD=0.187p PS=1.16u PD=1.78u
M$505 VSS|gnd \$295 B[2]|X VSS|gnd sg13_lv_nmos L=0.13u W=0.74u AS=0.14875p
+ AD=0.2886p PS=1.16u PD=2.26u
M$516 VSS|gnd CLK|X|clknet_2_0__leaf_clk \$320 VSS|gnd sg13_lv_nmos L=0.13u
+ W=0.74u AS=0.317325p AD=0.2516p PS=1.805u PD=2.16u
M$517 VSS|gnd \$320 \$263 VSS|gnd sg13_lv_nmos L=0.13u W=0.74u AS=0.317325p
+ AD=0.2516p PS=1.805u PD=2.16u
M$518 \$384 \$361 \$363 VSS|gnd sg13_lv_nmos L=0.13u W=0.42u AS=0.2373p
+ AD=0.0798p PS=1.97u PD=0.8u
M$519 \$363 \$383 \$362 VSS|gnd sg13_lv_nmos L=0.13u W=0.42u AS=0.0798p
+ AD=0.1296p PS=0.8u PD=1.52u
M$520 \$264 \$263 \$266 VSS|gnd sg13_lv_nmos L=0.13u W=0.42u AS=0.2373p
+ AD=0.0798p PS=1.97u PD=0.8u
M$521 \$266 \$320 \$265 VSS|gnd sg13_lv_nmos L=0.13u W=0.42u AS=0.0798p
+ AD=0.1296p PS=0.8u PD=1.52u
M$522 \$382 \$363 VSS|gnd VSS|gnd sg13_lv_nmos L=0.13u W=0.74u AS=0.2516p
+ AD=0.1626p PS=2.16u PD=1.415u
M$523 VSS|gnd L_HI|RESET_B|net42 \$403 VSS|gnd sg13_lv_nmos L=0.13u W=0.42u
+ AS=0.1626p AD=0.0609p PS=1.415u PD=0.71u
M$524 \$403 D|Y|_018_ \$362 VSS|gnd sg13_lv_nmos L=0.13u W=0.42u AS=0.0609p
+ AD=0.1428p PS=0.71u PD=1.52u
M$525 \$248 \$237 \$323 VSS|gnd sg13_lv_nmos L=0.13u W=0.42u AS=0.1296p
+ AD=0.0798p PS=1.52u PD=0.8u
M$526 \$323 \$269 \$268 VSS|gnd sg13_lv_nmos L=0.13u W=0.42u AS=0.0798p
+ AD=0.2373p PS=0.8u PD=1.97u
M$527 VSS|gnd \$237 \$269 VSS|gnd sg13_lv_nmos L=0.13u W=0.74u AS=0.317325p
+ AD=0.2516p PS=1.805u PD=2.16u
M$528 VSS|gnd CLK|X|clknet_2_0__leaf_clk \$237 VSS|gnd sg13_lv_nmos L=0.13u
+ W=0.74u AS=0.317325p AD=0.2516p PS=1.805u PD=2.16u
M$529 \$274 A|B|Y|_073_ \$311 VSS|gnd sg13_lv_nmos L=0.13u W=0.64u AS=0.2176p
+ AD=0.1216p PS=1.96u PD=1.02u
M$530 VSS|gnd A2|B|Y|_090_ \$311 VSS|gnd sg13_lv_nmos L=0.13u W=0.64u
+ AS=0.1331p AD=0.1216p PS=1.12u PD=1.02u
M$531 VSS|gnd \$274 A|B|C|X|_091_ VSS|gnd sg13_lv_nmos L=0.13u W=0.74u
+ AS=0.1331p AD=0.2516p PS=1.12u PD=2.16u
M$532 B|B_N|C|X|_077_ \$282 VSS|gnd VSS|gnd sg13_lv_nmos L=0.13u W=0.74u
+ AS=0.2516p AD=0.1331p PS=2.16u PD=1.12u
M$533 VSS|gnd A2|B|C|Y|_070_ \$316 VSS|gnd sg13_lv_nmos L=0.13u W=0.64u
+ AS=0.1331p AD=0.1216p PS=1.12u PD=1.02u
M$534 \$316 A|A1|A_N|B|C|Q|counter\[1\] \$282 VSS|gnd sg13_lv_nmos L=0.13u
+ W=0.64u AS=0.1216p AD=0.2176p PS=1.02u PD=1.96u
M$535 A|A1|X|_071_ \$284 VSS|gnd VSS|gnd sg13_lv_nmos L=0.13u W=0.74u
+ AS=0.2351p AD=0.15745p PS=2.16u PD=1.175u
M$536 VSS|gnd A1|B|B1|C|X|net28 \$284 VSS|gnd sg13_lv_nmos L=0.13u W=0.64u
+ AS=0.15745p AD=0.1216p PS=1.175u PD=1.02u
M$537 \$284 A|A1|B1|C|Q|counter\[3\] \$315 VSS|gnd sg13_lv_nmos L=0.13u W=0.64u
+ AS=0.1216p AD=0.0816p PS=1.02u PD=0.895u
M$538 \$315 A2|B|C|Y|_070_ VSS|gnd VSS|gnd sg13_lv_nmos L=0.13u W=0.64u
+ AS=0.0816p AD=0.2176p PS=0.895u PD=1.96u
M$539 VSS|gnd B|C|Y|_074_ \$422 VSS|gnd sg13_lv_nmos L=0.13u W=0.64u AS=0.1331p
+ AD=0.1216p PS=1.12u PD=1.02u
M$540 \$422 A|B|Y|_073_ \$372 VSS|gnd sg13_lv_nmos L=0.13u W=0.64u AS=0.1216p
+ AD=0.2176p PS=1.02u PD=1.96u
M$541 A2|X|_075_ \$372 VSS|gnd VSS|gnd sg13_lv_nmos L=0.13u W=0.74u AS=0.2516p
+ AD=0.1331p PS=2.16u PD=1.12u
M$542 VSS|gnd A_N|B1|Y|_072_ A|Y|_083_ VSS|gnd sg13_lv_nmos L=0.13u W=0.74u
+ AS=0.2516p AD=0.1406p PS=2.16u PD=1.12u
M$543 A|Y|_083_ A|A1|B1|C|Q|counter\[3\] \$309 VSS|gnd sg13_lv_nmos L=0.13u
+ W=0.74u AS=0.1406p AD=0.1406p PS=1.12u PD=1.12u
M$544 \$309 A1|A2|Y|_060_ VSS|gnd VSS|gnd sg13_lv_nmos L=0.13u W=0.74u
+ AS=0.1406p AD=0.2516p PS=1.12u PD=2.16u
M$545 VSS|gnd A2|B|Y|_032_ \$308 VSS|gnd sg13_lv_nmos L=0.13u W=0.74u
+ AS=0.2516p AD=0.1406p PS=2.16u PD=1.12u
M$546 \$308 A1|A2|Y|_060_ A|Y|_024_ VSS|gnd sg13_lv_nmos L=0.13u W=0.74u
+ AS=0.1406p AD=0.1406p PS=1.12u PD=1.12u
M$547 A|Y|_024_ A|B1|X|net30 VSS|gnd VSS|gnd sg13_lv_nmos L=0.13u W=0.74u
+ AS=0.1406p AD=0.2516p PS=1.12u PD=2.16u
M$548 \$253 \$239 \$331 VSS|gnd sg13_lv_nmos L=0.13u W=0.42u AS=0.1296p
+ AD=0.0798p PS=1.52u PD=0.8u
M$549 \$331 \$289 \$288 VSS|gnd sg13_lv_nmos L=0.13u W=0.42u AS=0.0798p
+ AD=0.2373p PS=0.8u PD=1.97u
M$550 VSS|gnd \$239 \$289 VSS|gnd sg13_lv_nmos L=0.13u W=0.74u AS=0.317325p
+ AD=0.2516p PS=1.805u PD=2.16u
M$551 VSS|gnd CLK|X|clknet_2_2__leaf_clk \$239 VSS|gnd sg13_lv_nmos L=0.13u
+ W=0.74u AS=0.317325p AD=0.2516p PS=1.805u PD=2.16u
M$552 \$257 \$241 \$332 VSS|gnd sg13_lv_nmos L=0.13u W=0.42u AS=0.1296p
+ AD=0.0798p PS=1.52u PD=0.8u
M$553 \$332 \$292 \$291 VSS|gnd sg13_lv_nmos L=0.13u W=0.42u AS=0.0798p
+ AD=0.2373p PS=0.8u PD=1.97u
M$554 VSS|gnd \$241 \$292 VSS|gnd sg13_lv_nmos L=0.13u W=0.74u AS=0.317325p
+ AD=0.2516p PS=1.805u PD=2.16u
M$555 VSS|gnd CLK|X|clknet_2_2__leaf_clk \$241 VSS|gnd sg13_lv_nmos L=0.13u
+ W=0.74u AS=0.317325p AD=0.2516p PS=1.805u PD=2.16u
M$572 \$381 \$383 \$398 VSS|gnd sg13_lv_nmos L=0.13u W=0.42u AS=0.12665p
+ AD=0.1428p PS=1.145u PD=1.52u
M$573 \$382 \$361 \$381 VSS|gnd sg13_lv_nmos L=0.13u W=0.74u AS=0.3473p
+ AD=0.12665p PS=2.71u PD=1.145u
M$574 \$383 CLK|X|clknet_2_0__leaf_clk VSS|gnd VSS|gnd sg13_lv_nmos L=0.13u
+ W=0.74u AS=0.2516p AD=0.317325p PS=2.16u PD=1.805u
M$575 VSS|gnd \$383 \$361 VSS|gnd sg13_lv_nmos L=0.13u W=0.74u AS=0.317325p
+ AD=0.2516p PS=1.805u PD=2.16u
M$576 B1|Y|_051_ A|A2|X|net2 \$409 VSS|gnd sg13_lv_nmos L=0.13u W=0.74u
+ AS=0.2516p AD=0.1406p PS=2.16u PD=1.12u
M$577 \$409 A|B|B1|Y|_068_ \$411 VSS|gnd sg13_lv_nmos L=0.13u W=0.74u
+ AS=0.1406p AD=0.1406p PS=1.12u PD=1.12u
M$578 \$411 A2|B|C|D|X|net27 \$410 VSS|gnd sg13_lv_nmos L=0.13u W=0.74u
+ AS=0.1406p AD=0.1406p PS=1.12u PD=1.12u
M$579 \$410 C|D|Y|_030_ VSS|gnd VSS|gnd sg13_lv_nmos L=0.13u W=0.74u AS=0.1406p
+ AD=0.2516p PS=1.12u PD=2.16u
M$580 VSS|gnd B|C|D|Y|_097_ \$414 VSS|gnd sg13_lv_nmos L=0.13u W=0.74u
+ AS=0.2886p AD=0.1406p PS=2.26u PD=1.12u
M$581 \$414 A2|B|C|D|X|net27 \$415 VSS|gnd sg13_lv_nmos L=0.13u W=0.74u
+ AS=0.1406p AD=0.1406p PS=1.12u PD=1.12u
M$582 \$415 A|B|D|X|_085_ B|Y|_100_ VSS|gnd sg13_lv_nmos L=0.13u W=0.74u
+ AS=0.1406p AD=0.2516p PS=1.12u PD=2.16u
M$583 VSS|gnd B|B_N|C|X|_077_ \$418 VSS|gnd sg13_lv_nmos L=0.13u W=0.74u
+ AS=0.2886p AD=0.1406p PS=2.26u PD=1.12u
M$584 \$418 B|C|Y|_074_ \$419 VSS|gnd sg13_lv_nmos L=0.13u W=0.74u AS=0.1406p
+ AD=0.1406p PS=1.12u PD=1.12u
M$585 \$419 A|B|Y|_073_ A|B|B1|Y|_078_ VSS|gnd sg13_lv_nmos L=0.13u W=0.74u
+ AS=0.1406p AD=0.2516p PS=1.12u PD=2.16u
M$586 A|B|Y|_076_ A|A1|X|_071_ \$420 VSS|gnd sg13_lv_nmos L=0.13u W=0.74u
+ AS=0.2516p AD=0.1406p PS=2.16u PD=1.12u
M$587 \$420 A|B|Y|_073_ \$421 VSS|gnd sg13_lv_nmos L=0.13u W=0.74u AS=0.1406p
+ AD=0.1406p PS=1.12u PD=1.12u
M$588 \$421 B|C|Y|_074_ VSS|gnd VSS|gnd sg13_lv_nmos L=0.13u W=0.74u AS=0.1406p
+ AD=0.2886p PS=1.12u PD=2.26u
M$589 VSS|gnd A2|A_N|B|X|_027_ \$405 VSS|gnd sg13_lv_nmos L=0.13u W=0.74u
+ AS=0.2516p AD=0.1406p PS=2.16u PD=1.12u
M$590 \$405 A|A1|X|net33 A1|A2|B_N|Y|_028_ VSS|gnd sg13_lv_nmos L=0.13u W=0.74u
+ AS=0.1406p AD=0.2516p PS=1.12u PD=2.16u
M$591 VSS|gnd \$366 \$365 VSS|gnd sg13_lv_nmos L=0.5u W=0.42u AS=0.1426p
+ AD=0.1428p PS=1.16u PD=1.52u
M$592 B1|X|net84 \$365 VSS|gnd VSS|gnd sg13_lv_nmos L=0.13u W=0.74u AS=0.2516p
+ AD=0.1426p PS=2.16u PD=1.16u
M$593 VSS|gnd A|B|Y|_076_ B|C|D|Y|_097_ VSS|gnd sg13_lv_nmos L=0.13u W=0.74u
+ AS=0.2516p AD=0.1406p PS=2.16u PD=1.12u
M$594 B|C|D|Y|_097_ B|B_N|C|X|_077_ VSS|gnd VSS|gnd sg13_lv_nmos L=0.13u
+ W=0.74u AS=0.1406p AD=0.2516p PS=1.12u PD=2.16u
M$595 A2|B|C|Y|_092_ A|B|Y|_073_ \$413 VSS|gnd sg13_lv_nmos L=0.13u W=0.74u
+ AS=0.2516p AD=0.1406p PS=2.16u PD=1.12u
M$596 \$413 A2|B|Y|_090_ VSS|gnd VSS|gnd sg13_lv_nmos L=0.13u W=0.74u
+ AS=0.1406p AD=0.2516p PS=1.12u PD=2.16u
M$597 VSS|gnd A1|B|B1|C|X|net28 \$424 VSS|gnd sg13_lv_nmos L=0.13u W=0.74u
+ AS=0.2516p AD=0.1406p PS=2.16u PD=1.12u
M$598 \$424 A|A1|A_N|B|C|Q|counter\[1\] A_N|B1|Y|_072_ VSS|gnd sg13_lv_nmos
+ L=0.13u W=0.74u AS=0.1406p AD=0.2516p PS=1.12u PD=2.16u
M$599 VSS|gnd A2|B|Y|_032_ \$426 VSS|gnd sg13_lv_nmos L=0.13u W=0.74u
+ AS=0.2516p AD=0.1406p PS=2.16u PD=1.12u
M$600 \$426 A|X|net70 A2|Y|_033_ VSS|gnd sg13_lv_nmos L=0.13u W=0.74u
+ AS=0.1406p AD=0.2516p PS=1.12u PD=2.16u
M$601 \$373 A2|A_N|B|X|_027_ VSS|gnd VSS|gnd sg13_lv_nmos L=0.13u W=0.55u
+ AS=0.187p AD=0.14505p PS=1.78u PD=1.15u
M$602 VSS|gnd B|X|net76 \$423 VSS|gnd sg13_lv_nmos L=0.13u W=0.74u AS=0.14505p
+ AD=0.1406p PS=1.15u PD=1.12u
M$603 \$423 \$373 A2|Y|_029_ VSS|gnd sg13_lv_nmos L=0.13u W=0.74u AS=0.1406p
+ AD=0.333p PS=1.12u PD=2.38u
M$604 VSS|gnd A|X|clknet_0_clk \$375 VSS|gnd sg13_lv_nmos L=0.13u W=4.44u
+ AS=0.9546p AD=0.8436p PS=7.76u PD=6.72u
M$610 VSS|gnd \$375 CLK|X|clknet_2_2__leaf_clk VSS|gnd sg13_lv_nmos L=0.13u
+ W=11.84u AS=2.2496p AD=2.3606p PS=17.92u PD=18.96u
M$626 VSS|gnd \$377 \$376 VSS|gnd sg13_lv_nmos L=0.5u W=0.42u AS=0.1426p
+ AD=0.1428p PS=1.16u PD=1.52u
M$627 B|X|net76 \$376 VSS|gnd VSS|gnd sg13_lv_nmos L=0.13u W=0.74u AS=0.2516p
+ AD=0.1426p PS=2.16u PD=1.16u
M$639 A|Q|net8 \$359 VSS|gnd VSS|gnd sg13_lv_nmos L=0.13u W=0.74u AS=0.2516p
+ AD=0.1406p PS=2.16u PD=1.12u
M$640 VSS|gnd \$381 \$359 VSS|gnd sg13_lv_nmos L=0.13u W=0.74u AS=0.1406p
+ AD=0.2516p PS=1.12u PD=2.16u
M$641 \$364 A|A1|X|net3 VSS|gnd VSS|gnd sg13_lv_nmos L=0.13u W=0.55u AS=0.187p
+ AD=0.14875p PS=1.78u PD=1.16u
M$642 VSS|gnd \$364 A|A1|X|net33 VSS|gnd sg13_lv_nmos L=0.13u W=0.74u
+ AS=0.14875p AD=0.2886p PS=1.16u PD=2.26u
M$643 \$399 A1|Y|_061_ VSS|gnd VSS|gnd sg13_lv_nmos L=0.15u W=0.74u AS=0.2516p
+ AD=0.1406p PS=2.16u PD=1.12u
M$644 VSS|gnd A|A2|Y|_034_ \$399 VSS|gnd sg13_lv_nmos L=0.15u W=0.74u
+ AS=0.1406p AD=0.1406p PS=1.12u PD=1.12u
M$645 \$399 B1|Y|_051_ D|Y|_018_ VSS|gnd sg13_lv_nmos L=0.15u W=0.74u
+ AS=0.1406p AD=0.2516p PS=1.12u PD=2.16u
M$647 VSS|gnd \$389 \$389 VSS|gnd sg13_lv_nmos L=0.13u W=0.3u AS=0.2043375p
+ AD=0.111p PS=1.585u PD=1.34u
M$648 \$387 \$388 VSS|gnd VSS|gnd sg13_lv_nmos L=0.13u W=0.795u AS=0.274275p
+ AD=0.2043375p PS=2.28u PD=1.585u
M$653 VSS|gnd A|B|C|X|_091_ \$370 VSS|gnd sg13_lv_nmos L=0.13u W=0.55u
+ AS=0.14875p AD=0.187p PS=1.16u PD=1.78u
M$654 A2|B|C|D|X|net27 \$370 VSS|gnd VSS|gnd sg13_lv_nmos L=0.13u W=0.74u
+ AS=0.2886p AD=0.14875p PS=2.26u PD=1.16u
M$657 A|B|D|X|_085_ \$392 VSS|gnd VSS|gnd sg13_lv_nmos L=0.13u W=0.74u
+ AS=0.2516p AD=0.1469p PS=2.16u PD=1.155u
M$658 VSS|gnd A|Y|_083_ \$392 VSS|gnd sg13_lv_nmos L=0.13u W=0.55u AS=0.1469p
+ AD=0.1045p PS=1.155u PD=0.93u
M$659 \$392 B|Y|_084_ VSS|gnd VSS|gnd sg13_lv_nmos L=0.13u W=0.55u AS=0.1045p
+ AD=0.187p PS=0.93u PD=1.78u
M$697 \$360 \$381 \$401 VSS|gnd sg13_lv_nmos L=0.13u W=0.42u AS=0.1428p
+ AD=0.0378p PS=1.52u PD=0.6u
M$698 \$401 L_HI|RESET_B|net42 VSS|gnd VSS|gnd sg13_lv_nmos L=0.13u W=0.42u
+ AS=0.0378p AD=0.0798p PS=0.6u PD=0.8u
M$699 VSS|gnd \$360 \$398 VSS|gnd sg13_lv_nmos L=0.13u W=0.42u AS=0.0798p
+ AD=0.1428p PS=0.8u PD=1.52u
M$700 VSS|gnd \$445 \$445 VSS|gnd sg13_lv_nmos L=0.13u W=0.3u AS=0.2043375p
+ AD=0.111p PS=1.585u PD=1.34u
M$701 VSS|gnd \$446 \$447 VSS|gnd sg13_lv_nmos L=0.13u W=0.795u AS=0.2043375p
+ AD=0.274275p PS=1.585u PD=2.28u
M$702 VSS|gnd A1|A2|B_N|Y|_094_ \$448 VSS|gnd sg13_lv_nmos L=0.13u W=0.55u
+ AS=0.17255p AD=0.187p PS=1.25u PD=1.78u
M$703 VSS|gnd \$448 D|Y|_015_ VSS|gnd sg13_lv_nmos L=0.13u W=0.74u AS=0.17255p
+ AD=0.1406p PS=1.25u PD=1.12u
M$704 D|Y|_015_ A|Y|_046_ VSS|gnd VSS|gnd sg13_lv_nmos L=0.13u W=0.74u
+ AS=0.1406p AD=0.2516p PS=1.12u PD=2.16u
M$705 \$429 A|Q|net8 VSS|gnd VSS|gnd sg13_lv_nmos L=0.13u W=0.42u AS=0.1428p
+ AD=0.0798p PS=1.52u PD=0.8u
M$706 VSS|gnd \$429 \$430 VSS|gnd sg13_lv_nmos L=0.5u W=0.42u AS=0.0798p
+ AD=0.1428p PS=0.8u PD=1.52u
M$707 \$384 \$382 \$402 VSS|gnd sg13_lv_nmos L=0.13u W=0.42u AS=0.1428p
+ AD=0.0378p PS=1.52u PD=0.6u
M$708 \$402 L_HI|RESET_B|net42 VSS|gnd VSS|gnd sg13_lv_nmos L=0.13u W=0.42u
+ AS=0.0378p AD=0.1701p PS=0.6u PD=1.65u
M$709 VSS|gnd \$430 \$450 VSS|gnd sg13_lv_nmos L=0.5u W=0.42u AS=0.1426p
+ AD=0.1428p PS=1.16u PD=1.52u
M$710 VSS|gnd \$450 A|X|net69 VSS|gnd sg13_lv_nmos L=0.13u W=0.74u AS=0.1426p
+ AD=0.2516p PS=1.16u PD=2.16u
M$711 VSS|gnd A|B1|X|net29 A|B|B1|Y|_068_ VSS|gnd sg13_lv_nmos L=0.13u W=0.74u
+ AS=0.2516p AD=0.2516p PS=2.16u PD=2.16u
M$712 VSS|gnd A|X|net69 A1|Y|_061_ VSS|gnd sg13_lv_nmos L=0.13u W=0.74u
+ AS=0.2516p AD=0.2516p PS=2.16u PD=2.16u
M$716 VSS|gnd \$452 \$451 VSS|gnd sg13_lv_nmos L=0.13u W=0.795u AS=0.2043375p
+ AD=0.274275p PS=1.585u PD=2.28u
M$717 VSS|gnd \$453 \$453 VSS|gnd sg13_lv_nmos L=0.13u W=0.3u AS=0.2043375p
+ AD=0.111p PS=1.585u PD=1.34u
M$719 VSS|gnd \$433 CLK|X|clknet_2_0__leaf_clk VSS|gnd sg13_lv_nmos L=0.13u
+ W=11.84u AS=2.3606p AD=2.2496p PS=18.96u PD=17.92u
M$735 VSS|gnd A|X|clknet_0_clk \$433 VSS|gnd sg13_lv_nmos L=0.13u W=4.44u
+ AS=0.8436p AD=0.9546p PS=6.72u PD=7.76u
M$741 \$366 \$367 VSS|gnd VSS|gnd sg13_lv_nmos L=0.5u W=0.42u AS=0.1428p
+ AD=0.0798p PS=1.52u PD=0.8u
M$742 VSS|gnd A|A1|A_N|B|C|Q|counter\[1\] \$367 VSS|gnd sg13_lv_nmos L=0.13u
+ W=0.42u AS=0.0798p AD=0.1428p PS=0.8u PD=1.52u
M$743 VSS|gnd C|D|Y|_030_ \$470 VSS|gnd sg13_lv_nmos L=0.13u W=0.74u AS=0.2886p
+ AD=0.1406p PS=2.26u PD=1.12u
M$744 \$470 A2|B|C|D|X|net27 \$472 VSS|gnd sg13_lv_nmos L=0.13u W=0.74u
+ AS=0.1406p AD=0.1406p PS=1.12u PD=1.12u
M$745 \$472 A|A1|X|net33 A1|A2|Y|_031_ VSS|gnd sg13_lv_nmos L=0.13u W=0.74u
+ AS=0.1406p AD=0.2516p PS=1.12u PD=2.16u
M$746 VSS|gnd A|B|Y|_076_ C|D|Y|_030_ VSS|gnd sg13_lv_nmos L=0.13u W=0.74u
+ AS=0.2516p AD=0.1406p PS=2.16u PD=1.12u
M$747 C|D|Y|_030_ \$454 VSS|gnd VSS|gnd sg13_lv_nmos L=0.13u W=0.74u AS=0.1406p
+ AD=0.17255p PS=1.12u PD=1.25u
M$748 VSS|gnd B|B_N|C|X|_077_ \$454 VSS|gnd sg13_lv_nmos L=0.13u W=0.55u
+ AS=0.17255p AD=0.187p PS=1.25u PD=1.78u
M$754 VSS|gnd A|B|B1|Y|_078_ \$478 VSS|gnd sg13_lv_nmos L=0.13u W=0.74u
+ AS=0.2553p AD=0.13875p PS=2.17u PD=1.115u
M$755 \$478 B|B2|C|Y|_079_ C|D|Y|_026_ VSS|gnd sg13_lv_nmos L=0.13u W=0.74u
+ AS=0.13875p AD=0.2664p PS=1.115u PD=1.46u
M$756 C|D|Y|_026_ A|A1|X|_071_ \$477 VSS|gnd sg13_lv_nmos L=0.13u W=0.74u
+ AS=0.2664p AD=0.0962p PS=1.46u PD=1u
M$757 \$477 A2|X|_075_ VSS|gnd VSS|gnd sg13_lv_nmos L=0.13u W=0.74u AS=0.0962p
+ AD=0.2516p PS=1u PD=2.16u
M$758 A|A1|Y|_087_ A|B|Y|_076_ \$476 VSS|gnd sg13_lv_nmos L=0.13u W=0.74u
+ AS=0.2516p AD=0.1406p PS=2.16u PD=1.12u
M$759 \$476 A|B|B1|Y|_078_ \$474 VSS|gnd sg13_lv_nmos L=0.13u W=0.74u
+ AS=0.1406p AD=0.1406p PS=1.12u PD=1.12u
M$760 \$474 B|B2|C|Y|_079_ \$475 VSS|gnd sg13_lv_nmos L=0.13u W=0.74u
+ AS=0.1406p AD=0.1406p PS=1.12u PD=1.12u
M$761 \$475 A|B|D|X|_085_ VSS|gnd VSS|gnd sg13_lv_nmos L=0.13u W=0.74u
+ AS=0.1406p AD=0.2516p PS=1.12u PD=2.16u
M$762 A|Y|_082_ A|B|Y|_076_ \$469 VSS|gnd sg13_lv_nmos L=0.13u W=0.74u
+ AS=0.2516p AD=0.1406p PS=2.16u PD=1.12u
M$763 \$469 A|B|B1|Y|_078_ \$468 VSS|gnd sg13_lv_nmos L=0.13u W=0.74u
+ AS=0.1406p AD=0.1406p PS=1.12u PD=1.12u
M$764 \$468 B|B2|C|Y|_079_ VSS|gnd VSS|gnd sg13_lv_nmos L=0.13u W=0.74u
+ AS=0.1406p AD=0.2886p PS=1.12u PD=2.26u
M$769 \$436 D|Y|_003_ \$466 VSS|gnd sg13_lv_nmos L=0.13u W=0.42u AS=0.1428p
+ AD=0.0609p PS=1.52u PD=0.71u
M$770 \$466 L_HI|RESET_B|net55 VSS|gnd VSS|gnd sg13_lv_nmos L=0.13u W=0.42u
+ AS=0.0609p AD=0.1626p PS=0.71u PD=1.415u
M$771 VSS|gnd \$482 \$437 VSS|gnd sg13_lv_nmos L=0.13u W=0.74u AS=0.1626p
+ AD=0.2516p PS=1.415u PD=2.16u
M$772 VSS|gnd L_HI|RESET_B|net55 \$465 VSS|gnd sg13_lv_nmos L=0.13u W=0.42u
+ AS=0.1701p AD=0.0378p PS=1.65u PD=0.6u
M$773 \$465 \$437 \$457 VSS|gnd sg13_lv_nmos L=0.13u W=0.42u AS=0.0378p
+ AD=0.1428p PS=0.6u PD=1.52u
M$774 \$459 \$438 \$439 VSS|gnd sg13_lv_nmos L=0.13u W=0.42u AS=0.12665p
+ AD=0.1428p PS=1.145u PD=1.52u
M$775 \$437 \$458 \$459 VSS|gnd sg13_lv_nmos L=0.13u W=0.74u AS=0.3473p
+ AD=0.12665p PS=2.71u PD=1.145u
M$776 \$439 \$440 VSS|gnd VSS|gnd sg13_lv_nmos L=0.13u W=0.42u AS=0.1428p
+ AD=0.0798p PS=1.52u PD=0.8u
M$777 VSS|gnd L_HI|RESET_B|net55 \$464 VSS|gnd sg13_lv_nmos L=0.13u W=0.42u
+ AS=0.0798p AD=0.0378p PS=0.8u PD=0.6u
M$778 \$464 \$459 \$440 VSS|gnd sg13_lv_nmos L=0.13u W=0.42u AS=0.0378p
+ AD=0.1428p PS=0.6u PD=1.52u
M$779 \$441 \$459 VSS|gnd VSS|gnd sg13_lv_nmos L=0.13u W=0.74u AS=0.2516p
+ AD=0.1406p PS=2.16u PD=1.12u
M$780 VSS|gnd \$441 A|Q|net15 VSS|gnd sg13_lv_nmos L=0.13u W=0.74u AS=0.1406p
+ AD=0.2516p PS=1.12u PD=2.16u
M$781 A|X|net70 \$460 VSS|gnd VSS|gnd sg13_lv_nmos L=0.13u W=0.74u AS=0.2516p
+ AD=0.1426p PS=2.16u PD=1.16u
M$782 VSS|gnd \$443 \$460 VSS|gnd sg13_lv_nmos L=0.5u W=0.42u AS=0.1426p
+ AD=0.1428p PS=1.16u PD=1.52u
M$783 \$443 \$444 VSS|gnd VSS|gnd sg13_lv_nmos L=0.5u W=0.42u AS=0.1428p
+ AD=0.0798p PS=1.52u PD=0.8u
M$784 VSS|gnd A|Q|net15 \$444 VSS|gnd sg13_lv_nmos L=0.13u W=0.42u AS=0.0798p
+ AD=0.1428p PS=0.8u PD=1.52u
M$785 VSS|gnd \$462 \$461 VSS|gnd sg13_lv_nmos L=0.13u W=0.795u AS=0.2043375p
+ AD=0.274275p PS=1.585u PD=2.28u
M$786 VSS|gnd \$463 \$463 VSS|gnd sg13_lv_nmos L=0.13u W=0.3u AS=0.2043375p
+ AD=0.111p PS=1.585u PD=1.34u
M$789 \$377 \$378 VSS|gnd VSS|gnd sg13_lv_nmos L=0.5u W=0.42u AS=0.1428p
+ AD=0.0798p PS=1.52u PD=0.8u
M$790 VSS|gnd A|Q|net14 \$378 VSS|gnd sg13_lv_nmos L=0.13u W=0.42u AS=0.0798p
+ AD=0.1428p PS=0.8u PD=1.52u
M$809 VSS|gnd A|Q|net8 \$508 VSS|gnd sg13_lv_nmos L=0.13u W=0.55u AS=0.14875p
+ AD=0.187p PS=1.16u PD=1.78u
M$810 BN[3]|X \$508 VSS|gnd VSS|gnd sg13_lv_nmos L=0.13u W=0.74u AS=0.2886p
+ AD=0.14875p PS=2.26u PD=1.16u
M$819 A|Q|net5 \$509 VSS|gnd VSS|gnd sg13_lv_nmos L=0.13u W=0.74u AS=0.2516p
+ AD=0.1406p PS=2.16u PD=1.12u
M$820 VSS|gnd \$536 \$509 VSS|gnd sg13_lv_nmos L=0.13u W=0.74u AS=0.1406p
+ AD=0.2516p PS=1.12u PD=2.16u
M$821 \$536 \$538 \$558 VSS|gnd sg13_lv_nmos L=0.13u W=0.42u AS=0.12665p
+ AD=0.1428p PS=1.145u PD=1.52u
M$822 \$537 \$511 \$536 VSS|gnd sg13_lv_nmos L=0.13u W=0.74u AS=0.3473p
+ AD=0.12665p PS=2.71u PD=1.145u
M$823 \$538 CLK|X|clknet_2_0__leaf_clk VSS|gnd VSS|gnd sg13_lv_nmos L=0.13u
+ W=0.74u AS=0.2516p AD=0.317325p PS=2.16u PD=1.805u
M$824 VSS|gnd \$538 \$511 VSS|gnd sg13_lv_nmos L=0.13u W=0.74u AS=0.317325p
+ AD=0.2516p PS=1.805u PD=2.16u
M$825 \$539 \$511 \$513 VSS|gnd sg13_lv_nmos L=0.13u W=0.42u AS=0.2373p
+ AD=0.0798p PS=1.97u PD=0.8u
M$826 \$513 \$538 \$512 VSS|gnd sg13_lv_nmos L=0.13u W=0.42u AS=0.0798p
+ AD=0.1296p PS=0.8u PD=1.52u
M$827 \$537 \$513 VSS|gnd VSS|gnd sg13_lv_nmos L=0.13u W=0.74u AS=0.2516p
+ AD=0.1626p PS=2.16u PD=1.415u
M$828 VSS|gnd L_HI|RESET_B|net54 \$582 VSS|gnd sg13_lv_nmos L=0.13u W=0.42u
+ AS=0.1626p AD=0.0609p PS=1.415u PD=0.71u
M$829 \$582 D|Y|_015_ \$512 VSS|gnd sg13_lv_nmos L=0.13u W=0.42u AS=0.0609p
+ AD=0.1428p PS=0.71u PD=1.52u
M$830 \$559 A1|X|net82 VSS|gnd VSS|gnd sg13_lv_nmos L=0.15u W=0.74u AS=0.2516p
+ AD=0.1406p PS=2.16u PD=1.12u
M$831 VSS|gnd A1|A2|B|Y|_093_ \$559 VSS|gnd sg13_lv_nmos L=0.15u W=0.74u
+ AS=0.1406p AD=0.1406p PS=1.12u PD=1.12u
M$832 \$559 A|B|B1|Y|_068_ A|Y|_046_ VSS|gnd sg13_lv_nmos L=0.15u W=0.74u
+ AS=0.1406p AD=0.2516p PS=1.12u PD=2.16u
M$833 VSS|gnd A|B1|X|net29 D|Y|_000_ VSS|gnd sg13_lv_nmos L=0.13u W=0.74u
+ AS=0.2516p AD=0.1406p PS=2.16u PD=1.12u
M$834 D|Y|_000_ A1|A2|B_N|Y|_094_ \$569 VSS|gnd sg13_lv_nmos L=0.13u W=0.74u
+ AS=0.1406p AD=0.1406p PS=1.12u PD=1.12u
M$835 \$569 A2|Y|_095_ VSS|gnd VSS|gnd sg13_lv_nmos L=0.13u W=0.74u AS=0.1406p
+ AD=0.2516p PS=1.12u PD=2.16u
M$836 \$517 \$542 \$519 VSS|gnd sg13_lv_nmos L=0.13u W=0.42u AS=0.1296p
+ AD=0.0798p PS=1.52u PD=0.8u
M$837 \$519 \$520 \$541 VSS|gnd sg13_lv_nmos L=0.13u W=0.42u AS=0.0798p
+ AD=0.2373p PS=0.8u PD=1.97u
M$838 \$520 \$542 VSS|gnd VSS|gnd sg13_lv_nmos L=0.13u W=0.74u AS=0.2516p
+ AD=0.317325p PS=2.16u PD=1.805u
M$839 VSS|gnd CLK|X|clknet_2_0__leaf_clk \$542 VSS|gnd sg13_lv_nmos L=0.13u
+ W=0.74u AS=0.317325p AD=0.2516p PS=1.805u PD=2.16u
M$840 \$560 \$542 \$521 VSS|gnd sg13_lv_nmos L=0.13u W=0.42u AS=0.1428p
+ AD=0.12665p PS=1.52u PD=1.145u
M$841 \$521 \$520 \$518 VSS|gnd sg13_lv_nmos L=0.13u W=0.74u AS=0.12665p
+ AD=0.3473p PS=1.145u PD=2.71u
M$842 \$523 \$521 VSS|gnd VSS|gnd sg13_lv_nmos L=0.13u W=0.74u AS=0.2516p
+ AD=0.1406p PS=2.16u PD=1.12u
M$843 VSS|gnd \$523 A|Q|net12 VSS|gnd sg13_lv_nmos L=0.13u W=0.74u AS=0.1406p
+ AD=0.2516p PS=1.12u PD=2.16u
M$844 A2|Y|_095_ B1|X|net81 \$561 VSS|gnd sg13_lv_nmos L=0.15u W=0.74u
+ AS=0.2516p AD=0.1406p PS=2.16u PD=1.12u
M$845 \$561 A2|B|C|Y|_092_ VSS|gnd VSS|gnd sg13_lv_nmos L=0.15u W=0.74u
+ AS=0.1406p AD=0.1406p PS=1.12u PD=1.12u
M$846 VSS|gnd A|A1|Y|_087_ \$561 VSS|gnd sg13_lv_nmos L=0.15u W=0.74u
+ AS=0.1406p AD=0.2516p PS=1.12u PD=2.16u
M$847 \$562 A1|A2|B|Y|_093_ VSS|gnd VSS|gnd sg13_lv_nmos L=0.15u W=0.74u
+ AS=0.2516p AD=0.1406p PS=2.16u PD=1.12u
M$848 VSS|gnd A2|D|Y|_038_ \$562 VSS|gnd sg13_lv_nmos L=0.15u W=0.74u
+ AS=0.1406p AD=0.1406p PS=1.12u PD=1.12u
M$849 \$562 B1|D|X|_048_ A2|Y|_055_ VSS|gnd sg13_lv_nmos L=0.15u W=0.74u
+ AS=0.1406p AD=0.2516p PS=1.12u PD=2.16u
M$850 VSS|gnd B1|D|X|_048_ \$575 VSS|gnd sg13_lv_nmos L=0.13u W=0.74u
+ AS=0.2516p AD=0.1406p PS=2.16u PD=1.12u
M$851 \$575 C|Y|_096_ \$576 VSS|gnd sg13_lv_nmos L=0.13u W=0.74u AS=0.1406p
+ AD=0.1406p PS=1.12u PD=1.12u
M$852 \$576 A2|B|C|D|X|net27 \$577 VSS|gnd sg13_lv_nmos L=0.13u W=0.74u
+ AS=0.1406p AD=0.1406p PS=1.12u PD=1.12u
M$853 \$577 A|A1|Y|_087_ A2|Y|_049_ VSS|gnd sg13_lv_nmos L=0.13u W=0.74u
+ AS=0.1406p AD=0.2516p PS=1.12u PD=2.16u
M$854 VSS|gnd A2|B|C|Y|_092_ A1|A2|B|Y|_093_ VSS|gnd sg13_lv_nmos L=0.13u
+ W=0.74u AS=0.2516p AD=0.1406p PS=2.16u PD=1.12u
M$855 A1|A2|B|Y|_093_ A|A1|Y|_087_ VSS|gnd VSS|gnd sg13_lv_nmos L=0.13u W=0.74u
+ AS=0.1406p AD=0.2516p PS=1.12u PD=2.16u
M$858 A2|A_N|B|Y|_035_ A2|B|C|Y|_092_ VSS|gnd VSS|gnd sg13_lv_nmos L=0.13u
+ W=0.77u AS=0.2618p AD=0.1463p PS=2.22u PD=1.15u
M$859 VSS|gnd A|B|D|X|_085_ A2|A_N|B|Y|_035_ VSS|gnd sg13_lv_nmos L=0.13u
+ W=0.77u AS=0.1463p AD=0.1694p PS=1.15u PD=1.21u
M$860 A2|A_N|B|Y|_035_ A|Y|_082_ VSS|gnd VSS|gnd sg13_lv_nmos L=0.13u W=0.77u
+ AS=0.1694p AD=0.2618p PS=1.21u PD=2.22u
M$861 VSS|gnd B|B2|C|Y|_079_ \$579 VSS|gnd sg13_lv_nmos L=0.13u W=0.64u
+ AS=0.1371p AD=0.1216p PS=1.12u PD=1.02u
M$862 \$579 A|B|B1|Y|_078_ \$578 VSS|gnd sg13_lv_nmos L=0.13u W=0.64u
+ AS=0.1216p AD=0.1216p PS=1.02u PD=1.02u
M$863 \$578 A|B|Y|_076_ \$507 VSS|gnd sg13_lv_nmos L=0.13u W=0.64u AS=0.1216p
+ AD=0.2176p PS=1.02u PD=1.96u
M$864 A|B|X|_081_ \$507 VSS|gnd VSS|gnd sg13_lv_nmos L=0.13u W=0.74u AS=0.2516p
+ AD=0.1371p PS=2.16u PD=1.12u
M$865 VSS|gnd A|clk \$525 VSS|gnd sg13_lv_nmos L=0.13u W=4.44u AS=0.9546p
+ AD=0.8436p PS=7.76u PD=6.72u
M$871 VSS|gnd \$525 A|X|clknet_0_clk VSS|gnd sg13_lv_nmos L=0.13u W=11.84u
+ AS=2.2496p AD=2.3606p PS=17.92u PD=18.96u
M$887 A2|A_N|B|X|_027_ \$480 VSS|gnd VSS|gnd sg13_lv_nmos L=0.13u W=0.74u
+ AS=0.2516p AD=0.1371p PS=2.16u PD=1.12u
M$888 VSS|gnd C|D|Y|_026_ \$473 VSS|gnd sg13_lv_nmos L=0.13u W=0.64u AS=0.1371p
+ AD=0.1216p PS=1.12u PD=1.02u
M$889 \$473 A|B|C|X|_091_ \$471 VSS|gnd sg13_lv_nmos L=0.13u W=0.64u AS=0.1216p
+ AD=0.1216p PS=1.02u PD=1.02u
M$890 \$471 A|B|D|X|_085_ \$480 VSS|gnd sg13_lv_nmos L=0.13u W=0.64u AS=0.1216p
+ AD=0.2176p PS=1.02u PD=1.96u
M$895 VSS|gnd A|B1|X|net30 D|Y|_003_ VSS|gnd sg13_lv_nmos L=0.13u W=0.74u
+ AS=0.2516p AD=0.1406p PS=2.16u PD=1.12u
M$896 D|Y|_003_ A1|A2|Y|_031_ \$467 VSS|gnd sg13_lv_nmos L=0.13u W=0.74u
+ AS=0.1406p AD=0.1406p PS=1.12u PD=1.12u
M$897 \$467 A2|Y|_033_ VSS|gnd VSS|gnd sg13_lv_nmos L=0.13u W=0.74u AS=0.1406p
+ AD=0.2516p PS=1.12u PD=2.16u
M$898 VSS|gnd \$548 \$548 VSS|gnd sg13_lv_nmos L=0.13u W=0.3u AS=0.2043375p
+ AD=0.111p PS=1.585u PD=1.34u
M$899 \$546 \$547 VSS|gnd VSS|gnd sg13_lv_nmos L=0.13u W=0.795u AS=0.274275p
+ AD=0.2043375p PS=2.28u PD=1.585u
M$900 \$436 \$438 \$482 VSS|gnd sg13_lv_nmos L=0.13u W=0.42u AS=0.1296p
+ AD=0.0798p PS=1.52u PD=0.8u
M$901 \$482 \$458 \$457 VSS|gnd sg13_lv_nmos L=0.13u W=0.42u AS=0.0798p
+ AD=0.2373p PS=0.8u PD=1.97u
M$902 VSS|gnd \$438 \$458 VSS|gnd sg13_lv_nmos L=0.13u W=0.74u AS=0.317325p
+ AD=0.2516p PS=1.805u PD=2.16u
M$903 VSS|gnd CLK|X|clknet_2_2__leaf_clk \$438 VSS|gnd sg13_lv_nmos L=0.13u
+ W=0.74u AS=0.317325p AD=0.2516p PS=1.805u PD=2.16u
M$904 VSS|gnd \$529 \$528 VSS|gnd sg13_lv_nmos L=0.5u W=0.42u AS=0.1426p
+ AD=0.1428p PS=1.16u PD=1.52u
M$905 B|X|net74 \$528 VSS|gnd VSS|gnd sg13_lv_nmos L=0.13u W=0.74u AS=0.2516p
+ AD=0.1426p PS=2.16u PD=1.16u
M$906 VSS|gnd A|X|net4 \$531 VSS|gnd sg13_lv_nmos L=0.13u W=0.55u AS=0.14875p
+ AD=0.187p PS=1.16u PD=1.78u
M$907 A|B1|X|net32 \$531 VSS|gnd VSS|gnd sg13_lv_nmos L=0.13u W=0.74u
+ AS=0.2886p AD=0.14875p PS=2.26u PD=1.16u
M$908 VSS|gnd A|B1|X|net32 \$532 VSS|gnd sg13_lv_nmos L=0.13u W=0.55u
+ AS=0.14875p AD=0.187p PS=1.16u PD=1.78u
M$909 A|B1|X|net30 \$532 VSS|gnd VSS|gnd sg13_lv_nmos L=0.13u W=0.74u
+ AS=0.2886p AD=0.14875p PS=2.26u PD=1.16u
M$932 \$533 A|Q|net15 VSS|gnd VSS|gnd sg13_lv_nmos L=0.13u W=0.55u AS=0.187p
+ AD=0.14875p PS=1.78u PD=1.16u
M$933 VSS|gnd \$533 B[3]|X VSS|gnd sg13_lv_nmos L=0.13u W=0.74u AS=0.14875p
+ AD=0.2886p PS=1.16u PD=2.26u
M$947 \$510 \$536 \$581 VSS|gnd sg13_lv_nmos L=0.13u W=0.42u AS=0.1428p
+ AD=0.0378p PS=1.52u PD=0.6u
M$948 \$581 L_HI|RESET_B|net54 VSS|gnd VSS|gnd sg13_lv_nmos L=0.13u W=0.42u
+ AS=0.0378p AD=0.0798p PS=0.6u PD=0.8u
M$949 VSS|gnd \$510 \$558 VSS|gnd sg13_lv_nmos L=0.13u W=0.42u AS=0.0798p
+ AD=0.1428p PS=0.8u PD=1.52u
M$950 VSS|gnd \$601 \$601 VSS|gnd sg13_lv_nmos L=0.13u W=0.3u AS=0.2043375p
+ AD=0.111p PS=1.585u PD=1.34u
M$951 VSS|gnd \$602 \$603 VSS|gnd sg13_lv_nmos L=0.13u W=0.795u AS=0.2043375p
+ AD=0.274275p PS=1.585u PD=2.28u
M$953 \$604 A|Q|net5 VSS|gnd VSS|gnd sg13_lv_nmos L=0.13u W=0.42u AS=0.1428p
+ AD=0.0798p PS=1.52u PD=0.8u
M$954 VSS|gnd \$604 \$605 VSS|gnd sg13_lv_nmos L=0.5u W=0.42u AS=0.0798p
+ AD=0.1428p PS=0.8u PD=1.52u
M$955 \$539 \$537 \$565 VSS|gnd sg13_lv_nmos L=0.13u W=0.42u AS=0.1428p
+ AD=0.0378p PS=1.52u PD=0.6u
M$956 \$565 L_HI|RESET_B|net54 VSS|gnd VSS|gnd sg13_lv_nmos L=0.13u W=0.42u
+ AS=0.0378p AD=0.1701p PS=0.6u PD=1.65u
M$957 VSS|gnd \$605 \$606 VSS|gnd sg13_lv_nmos L=0.5u W=0.42u AS=0.1426p
+ AD=0.1428p PS=1.16u PD=1.52u
M$958 VSS|gnd \$606 A1|X|net82 VSS|gnd sg13_lv_nmos L=0.13u W=0.74u AS=0.1426p
+ AD=0.2516p PS=1.16u PD=2.16u
M$960 VSS|gnd A1|A2|B|Y|_093_ \$629 VSS|gnd sg13_lv_nmos L=0.13u W=0.74u
+ AS=0.2516p AD=0.1406p PS=2.16u PD=1.12u
M$961 \$629 A|A1|X|net33 A1|A2|B_N|Y|_094_ VSS|gnd sg13_lv_nmos L=0.13u W=0.74u
+ AS=0.1406p AD=0.2516p PS=1.12u PD=2.16u
M$962 VSS|gnd \$607 \$607 VSS|gnd sg13_lv_nmos L=0.13u W=0.3u AS=0.2043375p
+ AD=0.111p PS=1.585u PD=1.34u
M$963 VSS|gnd \$608 \$609 VSS|gnd sg13_lv_nmos L=0.13u W=0.795u AS=0.2043375p
+ AD=0.274275p PS=1.585u PD=2.28u
M$964 VSS|gnd \$519 \$518 VSS|gnd sg13_lv_nmos L=0.13u W=0.74u AS=0.1626p
+ AD=0.2516p PS=1.415u PD=2.16u
M$965 \$517 D|Y|_000_ \$583 VSS|gnd sg13_lv_nmos L=0.13u W=0.42u AS=0.1428p
+ AD=0.0609p PS=1.52u PD=0.71u
M$966 VSS|gnd L_HI|RESET_B|net40 \$583 VSS|gnd sg13_lv_nmos L=0.13u W=0.42u
+ AS=0.1626p AD=0.0609p PS=1.415u PD=0.71u
M$967 A1|Y|_052_ \$611 \$632 VSS|gnd sg13_lv_nmos L=0.13u W=0.74u AS=0.333p
+ AD=0.1406p PS=2.38u PD=1.12u
M$968 \$632 B|X|net73 VSS|gnd VSS|gnd sg13_lv_nmos L=0.13u W=0.74u AS=0.1406p
+ AD=0.14505p PS=1.12u PD=1.15u
M$969 VSS|gnd A2|A_N|B|Y|_035_ \$611 VSS|gnd sg13_lv_nmos L=0.13u W=0.55u
+ AS=0.14505p AD=0.187p PS=1.15u PD=1.78u
M$970 VSS|gnd L_HI|RESET_B|net40 \$570 VSS|gnd sg13_lv_nmos L=0.13u W=0.42u
+ AS=0.1701p AD=0.0378p PS=1.65u PD=0.6u
M$971 \$570 \$518 \$541 VSS|gnd sg13_lv_nmos L=0.13u W=0.42u AS=0.0378p
+ AD=0.1428p PS=0.6u PD=1.52u
M$972 B|X|net73 \$612 VSS|gnd VSS|gnd sg13_lv_nmos L=0.13u W=0.74u AS=0.2516p
+ AD=0.1426p PS=2.16u PD=1.16u
M$973 VSS|gnd \$659 \$612 VSS|gnd sg13_lv_nmos L=0.5u W=0.42u AS=0.1426p
+ AD=0.1428p PS=1.16u PD=1.52u
M$974 \$659 \$613 VSS|gnd VSS|gnd sg13_lv_nmos L=0.5u W=0.42u AS=0.1428p
+ AD=0.0798p PS=1.52u PD=0.8u
M$975 VSS|gnd A|Q|net9 \$613 VSS|gnd sg13_lv_nmos L=0.13u W=0.42u AS=0.0798p
+ AD=0.1428p PS=0.8u PD=1.52u
M$977 \$560 \$522 VSS|gnd VSS|gnd sg13_lv_nmos L=0.13u W=0.42u AS=0.1428p
+ AD=0.0798p PS=1.52u PD=0.8u
M$978 VSS|gnd L_HI|RESET_B|net40 \$584 VSS|gnd sg13_lv_nmos L=0.13u W=0.42u
+ AS=0.0798p AD=0.0378p PS=0.8u PD=0.6u
M$979 \$584 \$521 \$522 VSS|gnd sg13_lv_nmos L=0.13u W=0.42u AS=0.0378p
+ AD=0.1428p PS=0.6u PD=1.52u
M$980 B1|X|net81 \$660 VSS|gnd VSS|gnd sg13_lv_nmos L=0.13u W=0.74u AS=0.2516p
+ AD=0.1426p PS=2.16u PD=1.16u
M$981 VSS|gnd \$661 \$660 VSS|gnd sg13_lv_nmos L=0.5u W=0.42u AS=0.1426p
+ AD=0.1428p PS=1.16u PD=1.52u
M$982 \$661 \$617 VSS|gnd VSS|gnd sg13_lv_nmos L=0.5u W=0.42u AS=0.1428p
+ AD=0.0798p PS=1.52u PD=0.8u
M$983 VSS|gnd A|Q|net12 \$617 VSS|gnd sg13_lv_nmos L=0.13u W=0.42u AS=0.0798p
+ AD=0.1428p PS=0.8u PD=1.52u
M$984 A1|A2|Y|_099_ A|A1|Y|_087_ \$639 VSS|gnd sg13_lv_nmos L=0.13u W=0.74u
+ AS=0.2516p AD=0.1406p PS=2.16u PD=1.12u
M$985 \$639 A2|B|C|D|X|net27 \$640 VSS|gnd sg13_lv_nmos L=0.13u W=0.74u
+ AS=0.1406p AD=0.1406p PS=1.12u PD=1.12u
M$986 \$640 C|Y|_096_ \$642 VSS|gnd sg13_lv_nmos L=0.13u W=0.74u AS=0.1406p
+ AD=0.1406p PS=1.12u PD=1.12u
M$987 \$642 B1|D|X|_098_ VSS|gnd VSS|gnd sg13_lv_nmos L=0.13u W=0.74u
+ AS=0.1406p AD=0.2516p PS=1.12u PD=2.16u
M$988 C|Y|_096_ A|Y|_082_ \$644 VSS|gnd sg13_lv_nmos L=0.13u W=0.74u AS=0.2516p
+ AD=0.1406p PS=2.16u PD=1.12u
M$989 \$644 B|C|Y|_086_ VSS|gnd VSS|gnd sg13_lv_nmos L=0.13u W=0.74u AS=0.1406p
+ AD=0.2516p PS=1.12u PD=2.16u
M$990 VSS|gnd B|C|D|Y|_097_ \$645 VSS|gnd sg13_lv_nmos L=0.13u W=0.74u
+ AS=0.2516p AD=0.1406p PS=2.16u PD=1.12u
M$991 \$645 A2|B|C|D|X|net27 \$646 VSS|gnd sg13_lv_nmos L=0.13u W=0.74u
+ AS=0.1406p AD=0.1406p PS=1.12u PD=1.12u
M$992 \$646 B|C|Y|_086_ \$647 VSS|gnd sg13_lv_nmos L=0.13u W=0.74u AS=0.1406p
+ AD=0.1406p PS=1.12u PD=1.12u
M$993 \$647 A|Y|_082_ B|Y|_040_ VSS|gnd sg13_lv_nmos L=0.13u W=0.74u AS=0.1406p
+ AD=0.2516p PS=1.12u PD=2.16u
M$995 VSS|gnd A2|B|C|D|X|net27 \$648 VSS|gnd sg13_lv_nmos L=0.13u W=0.74u
+ AS=0.2516p AD=0.1406p PS=2.16u PD=1.12u
M$996 \$648 B|C|Y|_086_ \$649 VSS|gnd sg13_lv_nmos L=0.13u W=0.74u AS=0.1406p
+ AD=0.1406p PS=1.12u PD=1.12u
M$997 \$649 A|B|X|_081_ \$650 VSS|gnd sg13_lv_nmos L=0.13u W=0.74u AS=0.1406p
+ AD=0.1406p PS=1.12u PD=1.12u
M$998 \$650 A|A2|X|net2 A2|Y|_053_ VSS|gnd sg13_lv_nmos L=0.13u W=0.74u
+ AS=0.1406p AD=0.2516p PS=1.12u PD=2.16u
M$999 A2|D|Y|_038_ A2|B|C|Y|_092_ VSS|gnd VSS|gnd sg13_lv_nmos L=0.13u W=0.77u
+ AS=0.2618p AD=0.1463p PS=2.22u PD=1.15u
M$1000 VSS|gnd A|B|D|X|_085_ A2|D|Y|_038_ VSS|gnd sg13_lv_nmos L=0.13u W=0.77u
+ AS=0.1463p AD=0.1694p PS=1.15u PD=1.21u
M$1001 A2|D|Y|_038_ A|B|X|_081_ VSS|gnd VSS|gnd sg13_lv_nmos L=0.13u W=0.77u
+ AS=0.1694p AD=0.2618p PS=1.21u PD=2.22u
M$1003 B|C|Y|_086_ A|B|D|X|_085_ VSS|gnd VSS|gnd sg13_lv_nmos L=0.13u W=0.74u
+ AS=0.2516p AD=0.2516p PS=2.16u PD=2.16u
M$1004 VSS|gnd B|B2|C|Y|_079_ \$654 VSS|gnd sg13_lv_nmos L=0.13u W=0.74u
+ AS=0.2516p AD=0.1406p PS=2.16u PD=1.12u
M$1005 \$654 A|B|B1|Y|_078_ C|Y|_080_ VSS|gnd sg13_lv_nmos L=0.13u W=0.74u
+ AS=0.1406p AD=0.2516p PS=1.12u PD=2.16u
M$1006 A2|Y|_057_ A|A2|X|net2 \$657 VSS|gnd sg13_lv_nmos L=0.13u W=0.74u
+ AS=0.2516p AD=0.1406p PS=2.16u PD=1.12u
M$1007 \$657 A|B|Y|_076_ \$655 VSS|gnd sg13_lv_nmos L=0.13u W=0.74u AS=0.1406p
+ AD=0.1406p PS=1.12u PD=1.12u
M$1008 \$655 C|Y|_080_ \$656 VSS|gnd sg13_lv_nmos L=0.13u W=0.74u AS=0.1406p
+ AD=0.1406p PS=1.12u PD=1.12u
M$1009 \$656 A2|D|Y|_038_ VSS|gnd VSS|gnd sg13_lv_nmos L=0.13u W=0.74u
+ AS=0.1406p AD=0.2516p PS=1.12u PD=2.16u
M$1010 VSS|gnd A2|D|Y|_038_ \$653 VSS|gnd sg13_lv_nmos L=0.13u W=0.74u
+ AS=0.2516p AD=0.1406p PS=2.16u PD=1.12u
M$1011 \$653 C|Y|_080_ \$652 VSS|gnd sg13_lv_nmos L=0.13u W=0.74u AS=0.1406p
+ AD=0.1406p PS=1.12u PD=1.12u
M$1012 \$652 A|B|Y|_076_ \$651 VSS|gnd sg13_lv_nmos L=0.13u W=0.74u AS=0.1406p
+ AD=0.1406p PS=1.12u PD=1.12u
M$1013 \$651 A|A1|X|net33 A1|A2|Y|_042_ VSS|gnd sg13_lv_nmos L=0.13u W=0.74u
+ AS=0.1406p AD=0.2516p PS=1.12u PD=2.16u
M$1018 A1|Y|_036_ A|A1|X|net33 \$643 VSS|gnd sg13_lv_nmos L=0.13u W=0.74u
+ AS=0.2516p AD=0.1406p PS=2.16u PD=1.12u
M$1019 \$643 A2|A_N|B|Y|_035_ VSS|gnd VSS|gnd sg13_lv_nmos L=0.13u W=0.74u
+ AS=0.1406p AD=0.2516p PS=1.12u PD=2.16u
M$1020 VSS|gnd A2|A_N|B|Y|_035_ \$620 VSS|gnd sg13_lv_nmos L=0.13u W=0.55u
+ AS=0.14505p AD=0.187p PS=1.15u PD=1.78u
M$1021 VSS|gnd B|X|net74 \$641 VSS|gnd sg13_lv_nmos L=0.13u W=0.74u AS=0.14505p
+ AD=0.1406p PS=1.15u PD=1.12u
M$1022 \$641 \$620 A2|Y|_037_ VSS|gnd sg13_lv_nmos L=0.13u W=0.74u AS=0.1406p
+ AD=0.333p PS=1.12u PD=2.38u
M$1024 \$593 D|Y|_004_ \$637 VSS|gnd sg13_lv_nmos L=0.13u W=0.42u AS=0.1428p
+ AD=0.0609p PS=1.52u PD=0.71u
M$1025 \$637 L_HI|RESET_B|net53 VSS|gnd VSS|gnd sg13_lv_nmos L=0.13u W=0.42u
+ AS=0.0609p AD=0.1626p PS=0.71u PD=1.415u
M$1026 VSS|gnd \$663 \$594 VSS|gnd sg13_lv_nmos L=0.13u W=0.74u AS=0.1626p
+ AD=0.2516p PS=1.415u PD=2.16u
M$1027 VSS|gnd L_HI|RESET_B|net53 \$635 VSS|gnd sg13_lv_nmos L=0.13u W=0.42u
+ AS=0.1701p AD=0.0378p PS=1.65u PD=0.6u
M$1028 \$635 \$594 \$622 VSS|gnd sg13_lv_nmos L=0.13u W=0.42u AS=0.0378p
+ AD=0.1428p PS=0.6u PD=1.52u
M$1029 \$529 \$530 VSS|gnd VSS|gnd sg13_lv_nmos L=0.5u W=0.42u AS=0.1428p
+ AD=0.0798p PS=1.52u PD=0.8u
M$1030 VSS|gnd A|Q|net16 \$530 VSS|gnd sg13_lv_nmos L=0.13u W=0.42u AS=0.0798p
+ AD=0.1428p PS=0.8u PD=1.52u
M$1031 \$623 \$595 \$596 VSS|gnd sg13_lv_nmos L=0.13u W=0.42u AS=0.12665p
+ AD=0.1428p PS=1.145u PD=1.52u
M$1032 \$594 \$673 \$623 VSS|gnd sg13_lv_nmos L=0.13u W=0.74u AS=0.3473p
+ AD=0.12665p PS=2.71u PD=1.145u
M$1033 \$596 \$597 VSS|gnd VSS|gnd sg13_lv_nmos L=0.13u W=0.42u AS=0.1428p
+ AD=0.0798p PS=1.52u PD=0.8u
M$1034 VSS|gnd L_HI|RESET_B|net53 \$633 VSS|gnd sg13_lv_nmos L=0.13u W=0.42u
+ AS=0.0798p AD=0.0378p PS=0.8u PD=0.6u
M$1035 \$633 \$623 \$597 VSS|gnd sg13_lv_nmos L=0.13u W=0.42u AS=0.0378p
+ AD=0.1428p PS=0.6u PD=1.52u
M$1036 \$598 \$623 VSS|gnd VSS|gnd sg13_lv_nmos L=0.13u W=0.74u AS=0.2516p
+ AD=0.1406p PS=2.16u PD=1.12u
M$1037 VSS|gnd \$598 A|Q|net16 VSS|gnd sg13_lv_nmos L=0.13u W=0.74u AS=0.1406p
+ AD=0.2516p PS=1.12u PD=2.16u
M$1039 VSS|gnd A|B1|X|net32 \$624 VSS|gnd sg13_lv_nmos L=0.13u W=0.55u
+ AS=0.14875p AD=0.187p PS=1.16u PD=1.78u
M$1040 VSS|gnd \$624 A|B1|X|net31 VSS|gnd sg13_lv_nmos L=0.13u W=0.74u
+ AS=0.14875p AD=0.2886p PS=1.16u PD=2.26u
M$1041 VSS|gnd B|Y|_043_ \$630 VSS|gnd sg13_lv_nmos L=0.13u W=0.74u AS=0.2516p
+ AD=0.1406p PS=2.16u PD=1.12u
M$1042 \$630 A|X|net67 A2|Y|_044_ VSS|gnd sg13_lv_nmos L=0.13u W=0.74u
+ AS=0.1406p AD=0.2516p PS=1.12u PD=2.16u
M$1044 VSS|gnd \$626 \$625 VSS|gnd sg13_lv_nmos L=0.13u W=0.795u AS=0.2043375p
+ AD=0.274275p PS=1.585u PD=2.28u
M$1045 VSS|gnd \$627 \$627 VSS|gnd sg13_lv_nmos L=0.13u W=0.3u AS=0.2043375p
+ AD=0.111p PS=1.585u PD=1.34u
M$1047 A|X|net67 \$666 VSS|gnd VSS|gnd sg13_lv_nmos L=0.13u W=0.74u AS=0.2516p
+ AD=0.1426p PS=2.16u PD=1.16u
M$1048 VSS|gnd \$667 \$666 VSS|gnd sg13_lv_nmos L=0.5u W=0.42u AS=0.1426p
+ AD=0.1428p PS=1.16u PD=1.52u
M$1049 \$667 \$628 VSS|gnd VSS|gnd sg13_lv_nmos L=0.5u W=0.42u AS=0.1428p
+ AD=0.0798p PS=1.52u PD=0.8u
M$1050 VSS|gnd A|Q|net18 \$628 VSS|gnd sg13_lv_nmos L=0.13u W=0.42u AS=0.0798p
+ AD=0.1428p PS=0.8u PD=1.52u
M$1064 VSS|gnd A|Q|net9 \$694 VSS|gnd sg13_lv_nmos L=0.13u W=0.55u AS=0.14875p
+ AD=0.187p PS=1.16u PD=1.78u
M$1065 BN[4]|X \$694 VSS|gnd VSS|gnd sg13_lv_nmos L=0.13u W=0.74u AS=0.2886p
+ AD=0.14875p PS=2.26u PD=1.16u
M$1066 VSS|gnd A1|A2|B_N|Y|_094_ \$757 VSS|gnd sg13_lv_nmos L=0.13u W=0.74u
+ AS=0.2516p AD=0.1406p PS=2.16u PD=1.12u
M$1067 \$757 A1|Y|_067_ D|Y|_007_ VSS|gnd sg13_lv_nmos L=0.13u W=0.74u
+ AS=0.1406p AD=0.1406p PS=1.12u PD=1.12u
M$1068 D|Y|_007_ A|B1|X|net29 VSS|gnd VSS|gnd sg13_lv_nmos L=0.13u W=0.74u
+ AS=0.1406p AD=0.2516p PS=1.12u PD=2.16u
M$1069 VSS|gnd A|B1|X|net29 D|Y|_019_ VSS|gnd sg13_lv_nmos L=0.13u W=0.74u
+ AS=0.2516p AD=0.1406p PS=2.16u PD=1.12u
M$1070 D|Y|_019_ A1|Y|_052_ \$631 VSS|gnd sg13_lv_nmos L=0.13u W=0.74u
+ AS=0.1406p AD=0.1406p PS=1.12u PD=1.12u
M$1071 \$631 A2|Y|_053_ VSS|gnd VSS|gnd sg13_lv_nmos L=0.13u W=0.74u AS=0.1406p
+ AD=0.2516p PS=1.12u PD=2.16u
M$1072 \$697 \$734 \$699 VSS|gnd sg13_lv_nmos L=0.13u W=0.42u AS=0.1296p
+ AD=0.0798p PS=1.52u PD=0.8u
M$1073 \$699 \$700 \$733 VSS|gnd sg13_lv_nmos L=0.13u W=0.42u AS=0.0798p
+ AD=0.2373p PS=0.8u PD=1.97u
M$1074 \$700 \$734 VSS|gnd VSS|gnd sg13_lv_nmos L=0.13u W=0.74u AS=0.2516p
+ AD=0.317325p PS=2.16u PD=1.805u
M$1075 VSS|gnd A|CLK|X|clknet_2_1__leaf_clk \$734 VSS|gnd sg13_lv_nmos L=0.13u
+ W=0.74u AS=0.317325p AD=0.2516p PS=1.805u PD=2.16u
M$1076 \$748 \$734 \$701 VSS|gnd sg13_lv_nmos L=0.13u W=0.42u AS=0.1428p
+ AD=0.12665p PS=1.52u PD=1.145u
M$1077 \$701 \$700 \$698 VSS|gnd sg13_lv_nmos L=0.13u W=0.74u AS=0.12665p
+ AD=0.3473p PS=1.145u PD=2.71u
M$1078 \$703 \$701 VSS|gnd VSS|gnd sg13_lv_nmos L=0.13u W=0.74u AS=0.2516p
+ AD=0.1406p PS=2.16u PD=1.12u
M$1079 VSS|gnd \$703 A|Q|net9 VSS|gnd sg13_lv_nmos L=0.13u W=0.74u AS=0.1406p
+ AD=0.2516p PS=1.12u PD=2.16u
M$1080 VSS|gnd A|CLK|X|clknet_2_1__leaf_clk Y VSS|gnd sg13_lv_nmos L=0.13u
+ W=0.74u AS=0.2516p AD=0.2516p PS=2.16u PD=2.16u
M$1081 B1|D|X|_048_ \$614 VSS|gnd VSS|gnd sg13_lv_nmos L=0.13u W=0.74u
+ AS=0.2516p AD=0.1331p PS=2.16u PD=1.12u
M$1082 VSS|gnd B|C|D|Y|_097_ \$634 VSS|gnd sg13_lv_nmos L=0.13u W=0.64u
+ AS=0.1331p AD=0.1216p PS=1.12u PD=1.02u
M$1083 \$634 A|A2|X|net2 \$614 VSS|gnd sg13_lv_nmos L=0.13u W=0.64u AS=0.1216p
+ AD=0.2176p PS=1.02u PD=1.96u
M$1084 VSS|gnd \$690 A|CLK|X|clknet_2_1__leaf_clk VSS|gnd sg13_lv_nmos L=0.13u
+ W=11.84u AS=2.3606p AD=2.2496p PS=18.96u PD=17.92u
M$1100 VSS|gnd A|X|clknet_0_clk \$690 VSS|gnd sg13_lv_nmos L=0.13u W=4.44u
+ AS=0.8436p AD=0.9546p PS=6.72u PD=7.76u
M$1106 \$615 A|A1|X|net33 \$636 VSS|gnd sg13_lv_nmos L=0.13u W=0.64u AS=0.2176p
+ AD=0.1216p PS=1.96u PD=1.02u
M$1107 VSS|gnd B|C|D|Y|_097_ \$636 VSS|gnd sg13_lv_nmos L=0.13u W=0.64u
+ AS=0.1331p AD=0.1216p PS=1.12u PD=1.02u
M$1108 VSS|gnd \$615 B1|D|X|_098_ VSS|gnd sg13_lv_nmos L=0.13u W=0.74u
+ AS=0.1331p AD=0.2516p PS=1.12u PD=2.16u
M$1109 VSS|gnd B|Y|_043_ \$765 VSS|gnd sg13_lv_nmos L=0.13u W=0.74u AS=0.2516p
+ AD=0.1406p PS=2.16u PD=1.12u
M$1110 \$765 A|X|net77 A1|Y|_056_ VSS|gnd sg13_lv_nmos L=0.13u W=0.74u
+ AS=0.1406p AD=0.2516p PS=1.12u PD=2.16u
M$1111 B|Y|_043_ A|Y|_082_ \$766 VSS|gnd sg13_lv_nmos L=0.13u W=0.74u
+ AS=0.2516p AD=0.1406p PS=2.16u PD=1.12u
M$1112 \$766 B|C|Y|_086_ \$767 VSS|gnd sg13_lv_nmos L=0.13u W=0.74u AS=0.1406p
+ AD=0.1406p PS=1.12u PD=1.12u
M$1113 \$767 A|B|C|X|_091_ \$768 VSS|gnd sg13_lv_nmos L=0.13u W=0.74u
+ AS=0.1406p AD=0.1406p PS=1.12u PD=1.12u
M$1114 \$768 C|D|Y|_026_ VSS|gnd VSS|gnd sg13_lv_nmos L=0.13u W=0.74u
+ AS=0.1406p AD=0.2516p PS=1.12u PD=2.16u
M$1115 VSS|gnd \$707 \$706 VSS|gnd sg13_lv_nmos L=0.5u W=0.42u AS=0.1426p
+ AD=0.1428p PS=1.16u PD=1.52u
M$1116 A|X|net77 \$706 VSS|gnd VSS|gnd sg13_lv_nmos L=0.13u W=0.74u AS=0.2516p
+ AD=0.1426p PS=2.16u PD=1.16u
M$1117 VSS|gnd A2|A_N|B|Y|_035_ \$769 VSS|gnd sg13_lv_nmos L=0.13u W=0.74u
+ AS=0.2516p AD=0.1406p PS=2.16u PD=1.12u
M$1118 \$769 A|A1|X|net3 B|Y|_045_ VSS|gnd sg13_lv_nmos L=0.13u W=0.74u
+ AS=0.1406p AD=0.1406p PS=1.12u PD=1.12u
M$1119 B|Y|_045_ B1|X|net60 VSS|gnd VSS|gnd sg13_lv_nmos L=0.13u W=0.74u
+ AS=0.1406p AD=0.2516p PS=1.12u PD=2.16u
M$1120 VSS|gnd A2|Y|_037_ \$638 VSS|gnd sg13_lv_nmos L=0.13u W=0.74u AS=0.2516p
+ AD=0.1406p PS=2.16u PD=1.12u
M$1121 \$638 A1|Y|_036_ D|Y|_004_ VSS|gnd sg13_lv_nmos L=0.13u W=0.74u
+ AS=0.1406p AD=0.1406p PS=1.12u PD=1.12u
M$1122 D|Y|_004_ A|B1|X|net30 VSS|gnd VSS|gnd sg13_lv_nmos L=0.13u W=0.74u
+ AS=0.1406p AD=0.2516p PS=1.12u PD=2.16u
M$1123 VSS|gnd B|Y|_040_ \$764 VSS|gnd sg13_lv_nmos L=0.13u W=0.74u AS=0.2516p
+ AD=0.1406p PS=2.16u PD=1.12u
M$1124 \$764 A|X|net72 A2|Y|_041_ VSS|gnd sg13_lv_nmos L=0.13u W=0.74u
+ AS=0.1406p AD=0.2516p PS=1.12u PD=2.16u
M$1125 \$593 \$595 \$663 VSS|gnd sg13_lv_nmos L=0.13u W=0.42u AS=0.1296p
+ AD=0.0798p PS=1.52u PD=0.8u
M$1126 \$663 \$673 \$622 VSS|gnd sg13_lv_nmos L=0.13u W=0.42u AS=0.0798p
+ AD=0.2373p PS=0.8u PD=1.97u
M$1127 VSS|gnd A|X|clknet_0_clk \$712 VSS|gnd sg13_lv_nmos L=0.13u W=4.44u
+ AS=0.9546p AD=0.8436p PS=7.76u PD=6.72u
M$1133 VSS|gnd \$712 A|CLK|X|clknet_2_3__leaf_clk VSS|gnd sg13_lv_nmos L=0.13u
+ W=11.84u AS=2.2496p AD=2.3606p PS=17.92u PD=18.96u
M$1149 VSS|gnd \$595 \$673 VSS|gnd sg13_lv_nmos L=0.13u W=0.74u AS=0.317325p
+ AD=0.2516p PS=1.805u PD=2.16u
M$1150 VSS|gnd CLK|X|clknet_2_2__leaf_clk \$595 VSS|gnd sg13_lv_nmos L=0.13u
+ W=0.74u AS=0.317325p AD=0.2516p PS=1.805u PD=2.16u
M$1151 VSS|gnd A|B1|X|net31 D|Y|_006_ VSS|gnd sg13_lv_nmos L=0.13u W=0.74u
+ AS=0.2516p AD=0.1406p PS=2.16u PD=1.12u
M$1152 D|Y|_006_ A1|A2|Y|_042_ \$762 VSS|gnd sg13_lv_nmos L=0.13u W=0.74u
+ AS=0.1406p AD=0.1406p PS=1.12u PD=1.12u
M$1153 \$762 A2|Y|_044_ VSS|gnd VSS|gnd sg13_lv_nmos L=0.13u W=0.74u AS=0.1406p
+ AD=0.2516p PS=1.12u PD=2.16u
M$1154 \$716 \$744 \$718 VSS|gnd sg13_lv_nmos L=0.13u W=0.42u AS=0.1296p
+ AD=0.0798p PS=1.52u PD=0.8u
M$1155 \$718 \$719 \$743 VSS|gnd sg13_lv_nmos L=0.13u W=0.42u AS=0.0798p
+ AD=0.2373p PS=0.8u PD=1.97u
M$1156 \$719 \$744 VSS|gnd VSS|gnd sg13_lv_nmos L=0.13u W=0.74u AS=0.2516p
+ AD=0.317325p PS=2.16u PD=1.805u
M$1157 VSS|gnd A|CLK|X|clknet_2_3__leaf_clk \$744 VSS|gnd sg13_lv_nmos L=0.13u
+ W=0.74u AS=0.317325p AD=0.2516p PS=1.805u PD=2.16u
M$1158 \$750 \$744 \$720 VSS|gnd sg13_lv_nmos L=0.13u W=0.42u AS=0.1428p
+ AD=0.12665p PS=1.52u PD=1.145u
M$1159 \$720 \$719 \$717 VSS|gnd sg13_lv_nmos L=0.13u W=0.74u AS=0.12665p
+ AD=0.3473p PS=1.145u PD=2.71u
M$1160 \$722 \$720 VSS|gnd VSS|gnd sg13_lv_nmos L=0.13u W=0.74u AS=0.2516p
+ AD=0.1406p PS=2.16u PD=1.12u
M$1161 VSS|gnd \$722 A|Q|net18 VSS|gnd sg13_lv_nmos L=0.13u W=0.74u AS=0.1406p
+ AD=0.2516p PS=1.12u PD=2.16u
M$1162 \$724 A|Q|net16 VSS|gnd VSS|gnd sg13_lv_nmos L=0.13u W=0.55u AS=0.187p
+ AD=0.14875p PS=1.78u PD=1.16u
M$1163 VSS|gnd \$724 B[4]|X VSS|gnd sg13_lv_nmos L=0.13u W=0.74u AS=0.14875p
+ AD=0.2886p PS=1.16u PD=2.26u
M$1174 \$770 D|Y|_007_ \$828 VSS|gnd sg13_lv_nmos L=0.13u W=0.42u AS=0.1428p
+ AD=0.0609p PS=1.52u PD=0.71u
M$1175 \$828 L_HI|RESET_B|net47 VSS|gnd VSS|gnd sg13_lv_nmos L=0.13u W=0.42u
+ AS=0.0609p AD=0.1626p PS=0.71u PD=1.415u
M$1176 VSS|gnd \$849 \$771 VSS|gnd sg13_lv_nmos L=0.13u W=0.74u AS=0.1626p
+ AD=0.2516p PS=1.415u PD=2.16u
M$1178 VSS|gnd \$731 \$731 VSS|gnd sg13_lv_nmos L=0.13u W=0.3u AS=0.2043375p
+ AD=0.111p PS=1.585u PD=1.34u
M$1179 \$729 \$730 VSS|gnd VSS|gnd sg13_lv_nmos L=0.13u W=0.795u AS=0.274275p
+ AD=0.2043375p PS=2.28u PD=1.585u
M$1182 \$773 \$774 VSS|gnd VSS|gnd sg13_lv_nmos L=0.13u W=0.42u AS=0.1428p
+ AD=0.0798p PS=1.52u PD=0.8u
M$1183 VSS|gnd L_HI|RESET_B|net47 \$832 VSS|gnd sg13_lv_nmos L=0.13u W=0.42u
+ AS=0.0798p AD=0.0378p PS=0.8u PD=0.6u
M$1184 \$832 \$805 \$774 VSS|gnd sg13_lv_nmos L=0.13u W=0.42u AS=0.0378p
+ AD=0.1428p PS=0.6u PD=1.52u
M$1187 \$775 \$805 VSS|gnd VSS|gnd sg13_lv_nmos L=0.13u W=0.74u AS=0.2516p
+ AD=0.1406p PS=2.16u PD=1.12u
M$1188 VSS|gnd \$775 A|Q|net19 VSS|gnd sg13_lv_nmos L=0.13u W=0.74u AS=0.1406p
+ AD=0.2516p PS=1.12u PD=2.16u
M$1189 VSS|gnd \$699 \$698 VSS|gnd sg13_lv_nmos L=0.13u W=0.74u AS=0.1626p
+ AD=0.2516p PS=1.415u PD=2.16u
M$1190 \$697 D|Y|_019_ \$759 VSS|gnd sg13_lv_nmos L=0.13u W=0.42u AS=0.1428p
+ AD=0.0609p PS=1.52u PD=0.71u
M$1191 VSS|gnd L_HI|RESET_B|net38 \$759 VSS|gnd sg13_lv_nmos L=0.13u W=0.42u
+ AS=0.1626p AD=0.0609p PS=1.415u PD=0.71u
M$1192 \$777 D|Y|_009_ \$834 VSS|gnd sg13_lv_nmos L=0.13u W=0.42u AS=0.1428p
+ AD=0.0609p PS=1.52u PD=0.71u
M$1193 \$834 L_HI|RESET_B|net43 VSS|gnd VSS|gnd sg13_lv_nmos L=0.13u W=0.42u
+ AS=0.0609p AD=0.1626p PS=0.71u PD=1.415u
M$1194 VSS|gnd \$854 \$778 VSS|gnd sg13_lv_nmos L=0.13u W=0.74u AS=0.1626p
+ AD=0.2516p PS=1.415u PD=2.16u
M$1195 VSS|gnd L_HI|RESET_B|net38 \$761 VSS|gnd sg13_lv_nmos L=0.13u W=0.42u
+ AS=0.1701p AD=0.0378p PS=1.65u PD=0.6u
M$1196 \$761 \$698 \$733 VSS|gnd sg13_lv_nmos L=0.13u W=0.42u AS=0.0378p
+ AD=0.1428p PS=0.6u PD=1.52u
M$1197 \$748 \$702 VSS|gnd VSS|gnd sg13_lv_nmos L=0.13u W=0.42u AS=0.1428p
+ AD=0.0798p PS=1.52u PD=0.8u
M$1198 VSS|gnd L_HI|RESET_B|net38 \$763 VSS|gnd sg13_lv_nmos L=0.13u W=0.42u
+ AS=0.0798p AD=0.0378p PS=0.8u PD=0.6u
M$1199 \$763 \$701 \$702 VSS|gnd sg13_lv_nmos L=0.13u W=0.42u AS=0.0378p
+ AD=0.1428p PS=0.6u PD=1.52u
M$1200 \$780 \$781 VSS|gnd VSS|gnd sg13_lv_nmos L=0.13u W=0.42u AS=0.1428p
+ AD=0.0798p PS=1.52u PD=0.8u
M$1201 VSS|gnd L_HI|RESET_B|net43 \$838 VSS|gnd sg13_lv_nmos L=0.13u W=0.42u
+ AS=0.0798p AD=0.0378p PS=0.8u PD=0.6u
M$1202 \$838 \$808 \$781 VSS|gnd sg13_lv_nmos L=0.13u W=0.42u AS=0.0378p
+ AD=0.1428p PS=0.6u PD=1.52u
M$1203 \$782 \$808 VSS|gnd VSS|gnd sg13_lv_nmos L=0.13u W=0.74u AS=0.2516p
+ AD=0.1406p PS=2.16u PD=1.12u
M$1204 VSS|gnd \$782 A|Q|net21 VSS|gnd sg13_lv_nmos L=0.13u W=0.74u AS=0.1406p
+ AD=0.2516p PS=1.12u PD=2.16u
M$1205 \$749 A1|A2|B|Y|_093_ VSS|gnd VSS|gnd sg13_lv_nmos L=0.15u W=0.74u
+ AS=0.2516p AD=0.1406p PS=2.16u PD=1.12u
M$1206 VSS|gnd A2|D|Y|_038_ \$749 VSS|gnd sg13_lv_nmos L=0.15u W=0.74u
+ AS=0.1406p AD=0.1406p PS=1.12u PD=1.12u
M$1207 \$749 B1|D|X|_098_ A1|A2|Y|_039_ VSS|gnd sg13_lv_nmos L=0.15u W=0.74u
+ AS=0.1406p AD=0.2516p PS=1.12u PD=2.16u
M$1214 \$784 D|Y|_021_ \$846 VSS|gnd sg13_lv_nmos L=0.13u W=0.42u AS=0.1428p
+ AD=0.0609p PS=1.52u PD=0.71u
M$1215 \$846 L_HI|RESET_B|net52 VSS|gnd VSS|gnd sg13_lv_nmos L=0.13u W=0.42u
+ AS=0.0609p AD=0.1626p PS=0.71u PD=1.415u
M$1216 VSS|gnd \$859 \$785 VSS|gnd sg13_lv_nmos L=0.13u W=0.74u AS=0.1626p
+ AD=0.2516p PS=1.415u PD=2.16u
M$1218 \$787 \$788 VSS|gnd VSS|gnd sg13_lv_nmos L=0.13u W=0.42u AS=0.1428p
+ AD=0.0798p PS=1.52u PD=0.8u
M$1219 VSS|gnd L_HI|RESET_B|net52 \$848 VSS|gnd sg13_lv_nmos L=0.13u W=0.42u
+ AS=0.0798p AD=0.0378p PS=0.8u PD=0.6u
M$1220 \$848 \$817 \$788 VSS|gnd sg13_lv_nmos L=0.13u W=0.42u AS=0.0378p
+ AD=0.1428p PS=0.6u PD=1.52u
M$1221 \$707 \$708 VSS|gnd VSS|gnd sg13_lv_nmos L=0.5u W=0.42u AS=0.1428p
+ AD=0.0798p PS=1.52u PD=0.8u
M$1222 VSS|gnd A|Q|net11 \$708 VSS|gnd sg13_lv_nmos L=0.13u W=0.42u AS=0.0798p
+ AD=0.1428p PS=0.8u PD=1.52u
M$1223 \$789 \$817 VSS|gnd VSS|gnd sg13_lv_nmos L=0.13u W=0.74u AS=0.2516p
+ AD=0.1406p PS=2.16u PD=1.12u
M$1224 VSS|gnd \$789 A|Q|net11 VSS|gnd sg13_lv_nmos L=0.13u W=0.74u AS=0.1406p
+ AD=0.2516p PS=1.12u PD=2.16u
M$1230 \$790 D|Y|_005_ \$840 VSS|gnd sg13_lv_nmos L=0.13u W=0.42u AS=0.1428p
+ AD=0.0609p PS=1.52u PD=0.71u
M$1231 \$840 L_HI|RESET_B|net51 VSS|gnd VSS|gnd sg13_lv_nmos L=0.13u W=0.42u
+ AS=0.0609p AD=0.1626p PS=0.71u PD=1.415u
M$1232 VSS|gnd \$863 \$791 VSS|gnd sg13_lv_nmos L=0.13u W=0.74u AS=0.1626p
+ AD=0.2516p PS=1.415u PD=2.16u
M$1233 VSS|gnd \$742 \$742 VSS|gnd sg13_lv_nmos L=0.13u W=0.3u AS=0.2043375p
+ AD=0.111p PS=1.585u PD=1.34u
M$1234 \$740 \$741 VSS|gnd VSS|gnd sg13_lv_nmos L=0.13u W=0.795u AS=0.274275p
+ AD=0.2043375p PS=2.28u PD=1.585u
M$1235 \$793 \$794 VSS|gnd VSS|gnd sg13_lv_nmos L=0.13u W=0.42u AS=0.1428p
+ AD=0.0798p PS=1.52u PD=0.8u
M$1236 VSS|gnd L_HI|RESET_B|net51 \$837 VSS|gnd sg13_lv_nmos L=0.13u W=0.42u
+ AS=0.0798p AD=0.0378p PS=0.8u PD=0.6u
M$1237 \$837 \$824 \$794 VSS|gnd sg13_lv_nmos L=0.13u W=0.42u AS=0.0378p
+ AD=0.1428p PS=0.6u PD=1.52u
M$1238 \$795 \$824 VSS|gnd VSS|gnd sg13_lv_nmos L=0.13u W=0.74u AS=0.2516p
+ AD=0.1406p PS=2.16u PD=1.12u
M$1239 VSS|gnd \$795 A|Q|net17 VSS|gnd sg13_lv_nmos L=0.13u W=0.74u AS=0.1406p
+ AD=0.2516p PS=1.12u PD=2.16u
M$1240 VSS|gnd \$718 \$717 VSS|gnd sg13_lv_nmos L=0.13u W=0.74u AS=0.1626p
+ AD=0.2516p PS=1.415u PD=2.16u
M$1241 \$716 D|Y|_006_ \$760 VSS|gnd sg13_lv_nmos L=0.13u W=0.42u AS=0.1428p
+ AD=0.0609p PS=1.52u PD=0.71u
M$1242 VSS|gnd L_HI|RESET_B|net49 \$760 VSS|gnd sg13_lv_nmos L=0.13u W=0.42u
+ AS=0.1626p AD=0.0609p PS=1.415u PD=0.71u
M$1243 VSS|gnd L_HI|RESET_B|net49 \$758 VSS|gnd sg13_lv_nmos L=0.13u W=0.42u
+ AS=0.1701p AD=0.0378p PS=1.65u PD=0.6u
M$1244 \$758 \$717 \$743 VSS|gnd sg13_lv_nmos L=0.13u W=0.42u AS=0.0378p
+ AD=0.1428p PS=0.6u PD=1.52u
M$1245 \$797 D|Y|_014_ \$833 VSS|gnd sg13_lv_nmos L=0.13u W=0.42u AS=0.1428p
+ AD=0.0609p PS=1.52u PD=0.71u
M$1246 \$833 L_HI|RESET_B|net58 VSS|gnd VSS|gnd sg13_lv_nmos L=0.13u W=0.42u
+ AS=0.0609p AD=0.1626p PS=0.71u PD=1.415u
M$1247 VSS|gnd \$867 \$798 VSS|gnd sg13_lv_nmos L=0.13u W=0.74u AS=0.1626p
+ AD=0.2516p PS=1.415u PD=2.16u
M$1248 \$750 \$721 VSS|gnd VSS|gnd sg13_lv_nmos L=0.13u W=0.42u AS=0.1428p
+ AD=0.0798p PS=1.52u PD=0.8u
M$1249 VSS|gnd L_HI|RESET_B|net49 \$756 VSS|gnd sg13_lv_nmos L=0.13u W=0.42u
+ AS=0.0798p AD=0.0378p PS=0.8u PD=0.6u
M$1250 \$756 \$720 \$721 VSS|gnd sg13_lv_nmos L=0.13u W=0.42u AS=0.0378p
+ AD=0.1428p PS=0.6u PD=1.52u
M$1251 \$800 \$801 VSS|gnd VSS|gnd sg13_lv_nmos L=0.13u W=0.42u AS=0.1428p
+ AD=0.0798p PS=1.52u PD=0.8u
M$1252 VSS|gnd L_HI|RESET_B|net58 \$830 VSS|gnd sg13_lv_nmos L=0.13u W=0.42u
+ AS=0.0798p AD=0.0378p PS=0.8u PD=0.6u
M$1253 \$830 \$827 \$801 VSS|gnd sg13_lv_nmos L=0.13u W=0.42u AS=0.0378p
+ AD=0.1428p PS=0.6u PD=1.52u
M$1256 \$802 \$827 VSS|gnd VSS|gnd sg13_lv_nmos L=0.13u W=0.74u AS=0.2516p
+ AD=0.1406p PS=2.16u PD=1.12u
M$1257 VSS|gnd \$802 A|Q|net26 VSS|gnd sg13_lv_nmos L=0.13u W=0.74u AS=0.1406p
+ AD=0.2516p PS=1.12u PD=2.16u
M$1277 VSS|gnd L_HI|RESET_B|net47 \$829 VSS|gnd sg13_lv_nmos L=0.13u W=0.42u
+ AS=0.1701p AD=0.0378p PS=1.65u PD=0.6u
M$1278 \$829 \$771 \$804 VSS|gnd sg13_lv_nmos L=0.13u W=0.42u AS=0.0378p
+ AD=0.1428p PS=0.6u PD=1.52u
M$1279 \$805 \$772 \$773 VSS|gnd sg13_lv_nmos L=0.13u W=0.42u AS=0.12665p
+ AD=0.1428p PS=1.145u PD=1.52u
M$1280 \$771 \$869 \$805 VSS|gnd sg13_lv_nmos L=0.13u W=0.74u AS=0.3473p
+ AD=0.12665p PS=2.71u PD=1.145u
M$1281 A1|Y|_067_ A|X|net66 VSS|gnd VSS|gnd sg13_lv_nmos L=0.13u W=0.74u
+ AS=0.2516p AD=0.2516p PS=2.16u PD=2.16u
M$1282 A1|Y|_066_ A|X|net65 VSS|gnd VSS|gnd sg13_lv_nmos L=0.13u W=0.74u
+ AS=0.2516p AD=0.2516p PS=2.16u PD=2.16u
M$1283 VSS|gnd L_HI|RESET_B|net43 \$836 VSS|gnd sg13_lv_nmos L=0.13u W=0.42u
+ AS=0.1701p AD=0.0378p PS=1.65u PD=0.6u
M$1284 \$836 \$778 \$807 VSS|gnd sg13_lv_nmos L=0.13u W=0.42u AS=0.0378p
+ AD=0.1428p PS=0.6u PD=1.52u
M$1285 \$808 \$779 \$780 VSS|gnd sg13_lv_nmos L=0.13u W=0.42u AS=0.12665p
+ AD=0.1428p PS=1.145u PD=1.52u
M$1286 \$778 \$870 \$808 VSS|gnd sg13_lv_nmos L=0.13u W=0.74u AS=0.3473p
+ AD=0.12665p PS=2.71u PD=1.145u
M$1287 \$809 A|Q|net10 VSS|gnd VSS|gnd sg13_lv_nmos L=0.13u W=0.42u AS=0.1428p
+ AD=0.0798p PS=1.52u PD=0.8u
M$1288 VSS|gnd \$809 \$810 VSS|gnd sg13_lv_nmos L=0.5u W=0.42u AS=0.0798p
+ AD=0.1428p PS=0.8u PD=1.52u
M$1289 VSS|gnd \$810 \$811 VSS|gnd sg13_lv_nmos L=0.5u W=0.42u AS=0.1426p
+ AD=0.1428p PS=1.16u PD=1.52u
M$1290 VSS|gnd \$811 A|X|net68 VSS|gnd sg13_lv_nmos L=0.13u W=0.74u AS=0.1426p
+ AD=0.2516p PS=1.16u PD=2.16u
M$1291 A1|Y|_054_ A|X|net68 \$843 VSS|gnd sg13_lv_nmos L=0.13u W=0.74u
+ AS=0.2516p AD=0.1406p PS=2.16u PD=1.12u
M$1292 \$843 B|Y|_040_ VSS|gnd VSS|gnd sg13_lv_nmos L=0.13u W=0.74u AS=0.1406p
+ AD=0.2516p PS=1.12u PD=2.16u
M$1294 A1|Y|_064_ A|X|net63 VSS|gnd VSS|gnd sg13_lv_nmos L=0.13u W=0.74u
+ AS=0.2516p AD=0.2516p PS=2.16u PD=2.16u
M$1298 VSS|gnd L_HI|RESET_B|net52 \$847 VSS|gnd sg13_lv_nmos L=0.13u W=0.42u
+ AS=0.1701p AD=0.0378p PS=1.65u PD=0.6u
M$1299 \$847 \$785 \$816 VSS|gnd sg13_lv_nmos L=0.13u W=0.42u AS=0.0378p
+ AD=0.1428p PS=0.6u PD=1.52u
M$1300 \$817 \$786 \$787 VSS|gnd sg13_lv_nmos L=0.13u W=0.42u AS=0.12665p
+ AD=0.1428p PS=1.145u PD=1.52u
M$1301 \$785 \$873 \$817 VSS|gnd sg13_lv_nmos L=0.13u W=0.74u AS=0.3473p
+ AD=0.12665p PS=2.71u PD=1.145u
M$1302 VSS|gnd A|B1|X|net30 D|Y|_011_ VSS|gnd sg13_lv_nmos L=0.13u W=0.74u
+ AS=0.2516p AD=0.1406p PS=2.16u PD=1.12u
M$1303 D|Y|_011_ B|Y|_045_ VSS|gnd VSS|gnd sg13_lv_nmos L=0.13u W=0.74u
+ AS=0.1406p AD=0.2516p PS=1.12u PD=2.16u
M$1305 B1|X|net60 \$819 VSS|gnd VSS|gnd sg13_lv_nmos L=0.13u W=0.74u AS=0.2516p
+ AD=0.1426p PS=2.16u PD=1.16u
M$1306 VSS|gnd \$861 \$819 VSS|gnd sg13_lv_nmos L=0.5u W=0.42u AS=0.1426p
+ AD=0.1428p PS=1.16u PD=1.52u
M$1307 \$861 \$820 VSS|gnd VSS|gnd sg13_lv_nmos L=0.5u W=0.42u AS=0.1428p
+ AD=0.0798p PS=1.52u PD=0.8u
M$1308 VSS|gnd A|Q|net23 \$820 VSS|gnd sg13_lv_nmos L=0.13u W=0.42u AS=0.0798p
+ AD=0.1428p PS=0.8u PD=1.52u
M$1309 VSS|gnd L_HI|RESET_B|net51 \$839 VSS|gnd sg13_lv_nmos L=0.13u W=0.42u
+ AS=0.1701p AD=0.0378p PS=1.65u PD=0.6u
M$1310 \$839 \$791 \$823 VSS|gnd sg13_lv_nmos L=0.13u W=0.42u AS=0.0378p
+ AD=0.1428p PS=0.6u PD=1.52u
M$1311 \$824 \$792 \$793 VSS|gnd sg13_lv_nmos L=0.13u W=0.42u AS=0.12665p
+ AD=0.1428p PS=1.145u PD=1.52u
M$1312 \$791 \$876 \$824 VSS|gnd sg13_lv_nmos L=0.13u W=0.74u AS=0.3473p
+ AD=0.12665p PS=2.71u PD=1.145u
M$1316 VSS|gnd L_HI|RESET_B|net58 \$831 VSS|gnd sg13_lv_nmos L=0.13u W=0.42u
+ AS=0.1701p AD=0.0378p PS=1.65u PD=0.6u
M$1317 \$831 \$798 \$826 VSS|gnd sg13_lv_nmos L=0.13u W=0.42u AS=0.0378p
+ AD=0.1428p PS=0.6u PD=1.52u
M$1318 \$827 \$799 \$800 VSS|gnd sg13_lv_nmos L=0.13u W=0.42u AS=0.12665p
+ AD=0.1428p PS=1.145u PD=1.52u
M$1319 \$798 \$878 \$827 VSS|gnd sg13_lv_nmos L=0.13u W=0.74u AS=0.3473p
+ AD=0.12665p PS=2.71u PD=1.145u
M$1330 \$770 \$772 \$849 VSS|gnd sg13_lv_nmos L=0.13u W=0.42u AS=0.1296p
+ AD=0.0798p PS=1.52u PD=0.8u
M$1331 \$849 \$869 \$804 VSS|gnd sg13_lv_nmos L=0.13u W=0.42u AS=0.0798p
+ AD=0.2373p PS=0.8u PD=1.97u
M$1332 \$906 \$975 \$908 VSS|gnd sg13_lv_nmos L=0.13u W=0.42u AS=0.1296p
+ AD=0.0798p PS=1.52u PD=0.8u
M$1333 \$908 \$909 \$974 VSS|gnd sg13_lv_nmos L=0.13u W=0.42u AS=0.0798p
+ AD=0.2373p PS=0.8u PD=1.97u
M$1334 VSS|gnd \$772 \$869 VSS|gnd sg13_lv_nmos L=0.13u W=0.74u AS=0.317325p
+ AD=0.2516p PS=1.805u PD=2.16u
M$1335 VSS|gnd A|CLK|X|clknet_2_1__leaf_clk \$772 VSS|gnd sg13_lv_nmos L=0.13u
+ W=0.74u AS=0.317325p AD=0.2516p PS=1.805u PD=2.16u
M$1336 \$909 \$975 VSS|gnd VSS|gnd sg13_lv_nmos L=0.13u W=0.74u AS=0.2516p
+ AD=0.317325p PS=2.16u PD=1.805u
M$1337 VSS|gnd A|CLK|X|clknet_2_1__leaf_clk \$975 VSS|gnd sg13_lv_nmos L=0.13u
+ W=0.74u AS=0.317325p AD=0.2516p PS=1.805u PD=2.16u
M$1338 \$997 \$975 \$910 VSS|gnd sg13_lv_nmos L=0.13u W=0.42u AS=0.1428p
+ AD=0.12665p PS=1.52u PD=1.145u
M$1339 \$910 \$909 \$907 VSS|gnd sg13_lv_nmos L=0.13u W=0.74u AS=0.12665p
+ AD=0.3473p PS=1.145u PD=2.71u
M$1340 VSS|gnd \$915 \$914 VSS|gnd sg13_lv_nmos L=0.5u W=0.42u AS=0.1426p
+ AD=0.1428p PS=1.16u PD=1.52u
M$1341 A|X|net66 \$914 VSS|gnd VSS|gnd sg13_lv_nmos L=0.13u W=0.74u AS=0.2516p
+ AD=0.1426p PS=2.16u PD=1.16u
M$1342 VSS|gnd A|B1|X|net29 D|Y|_009_ VSS|gnd sg13_lv_nmos L=0.13u W=0.74u
+ AS=0.2516p AD=0.1406p PS=2.16u PD=1.12u
M$1343 D|Y|_009_ A1|Y|_065_ \$1012 VSS|gnd sg13_lv_nmos L=0.13u W=0.74u
+ AS=0.1406p AD=0.1406p PS=1.12u PD=1.12u
M$1344 \$1012 A1|A2|B_N|Y|_028_ VSS|gnd VSS|gnd sg13_lv_nmos L=0.13u W=0.74u
+ AS=0.1406p AD=0.2516p PS=1.12u PD=2.16u
M$1345 \$777 \$779 \$854 VSS|gnd sg13_lv_nmos L=0.13u W=0.42u AS=0.1296p
+ AD=0.0798p PS=1.52u PD=0.8u
M$1346 \$854 \$870 \$807 VSS|gnd sg13_lv_nmos L=0.13u W=0.42u AS=0.0798p
+ AD=0.2373p PS=0.8u PD=1.97u
M$1347 VSS|gnd \$779 \$870 VSS|gnd sg13_lv_nmos L=0.13u W=0.74u AS=0.317325p
+ AD=0.2516p PS=1.805u PD=2.16u
M$1348 VSS|gnd A|CLK|X|clknet_2_1__leaf_clk \$779 VSS|gnd sg13_lv_nmos L=0.13u
+ W=0.74u AS=0.317325p AD=0.2516p PS=1.805u PD=2.16u
M$1349 A1|Y|_065_ A|X|net62 VSS|gnd VSS|gnd sg13_lv_nmos L=0.13u W=0.74u
+ AS=0.2516p AD=0.2516p PS=2.16u PD=2.16u
M$1350 \$978 \$979 \$998 VSS|gnd sg13_lv_nmos L=0.13u W=0.42u AS=0.12665p
+ AD=0.1428p PS=1.145u PD=1.52u
M$1351 \$981 \$921 \$978 VSS|gnd sg13_lv_nmos L=0.13u W=0.74u AS=0.3473p
+ AD=0.12665p PS=2.71u PD=1.145u
M$1352 \$979 A|CLK|X|clknet_2_1__leaf_clk VSS|gnd VSS|gnd sg13_lv_nmos L=0.13u
+ W=0.74u AS=0.2516p AD=0.317325p PS=2.16u PD=1.805u
M$1353 VSS|gnd \$979 \$921 VSS|gnd sg13_lv_nmos L=0.13u W=0.74u AS=0.317325p
+ AD=0.2516p PS=1.805u PD=2.16u
M$1354 \$980 \$921 \$923 VSS|gnd sg13_lv_nmos L=0.13u W=0.42u AS=0.2373p
+ AD=0.0798p PS=1.97u PD=0.8u
M$1355 \$923 \$979 \$922 VSS|gnd sg13_lv_nmos L=0.13u W=0.42u AS=0.0798p
+ AD=0.1296p PS=0.8u PD=1.52u
M$1356 VSS|gnd A|B1|X|net32 D|Y|_020_ VSS|gnd sg13_lv_nmos L=0.13u W=0.74u
+ AS=0.2516p AD=0.1406p PS=2.16u PD=1.12u
M$1357 D|Y|_020_ A1|Y|_054_ \$841 VSS|gnd sg13_lv_nmos L=0.13u W=0.74u
+ AS=0.1406p AD=0.1406p PS=1.12u PD=1.12u
M$1358 \$841 A2|Y|_055_ VSS|gnd VSS|gnd sg13_lv_nmos L=0.13u W=0.74u AS=0.1406p
+ AD=0.2516p PS=1.12u PD=2.16u
M$1359 \$981 \$923 VSS|gnd VSS|gnd sg13_lv_nmos L=0.13u W=0.74u AS=0.2516p
+ AD=0.1626p PS=2.16u PD=1.415u
M$1360 VSS|gnd L_HI|RESET_B|net34 \$1015 VSS|gnd sg13_lv_nmos L=0.13u W=0.42u
+ AS=0.1626p AD=0.0609p PS=1.415u PD=0.71u
M$1361 \$1015 D|Y|_020_ \$922 VSS|gnd sg13_lv_nmos L=0.13u W=0.42u AS=0.0609p
+ AD=0.1428p PS=0.71u PD=1.52u
M$1362 \$924 \$983 \$926 VSS|gnd sg13_lv_nmos L=0.13u W=0.42u AS=0.1296p
+ AD=0.0798p PS=1.52u PD=0.8u
M$1363 \$926 \$927 \$982 VSS|gnd sg13_lv_nmos L=0.13u W=0.42u AS=0.0798p
+ AD=0.2373p PS=0.8u PD=1.97u
M$1364 VSS|gnd A|B1|X|net29 D|Y|_010_ VSS|gnd sg13_lv_nmos L=0.13u W=0.74u
+ AS=0.2516p AD=0.1406p PS=2.16u PD=1.12u
M$1365 D|Y|_010_ A1|Y|_064_ \$845 VSS|gnd sg13_lv_nmos L=0.13u W=0.74u
+ AS=0.1406p AD=0.1406p PS=1.12u PD=1.12u
M$1366 \$845 A1|A2|Y|_031_ VSS|gnd VSS|gnd sg13_lv_nmos L=0.13u W=0.74u
+ AS=0.1406p AD=0.2516p PS=1.12u PD=2.16u
M$1367 \$927 \$983 VSS|gnd VSS|gnd sg13_lv_nmos L=0.13u W=0.74u AS=0.2516p
+ AD=0.317325p PS=2.16u PD=1.805u
M$1368 VSS|gnd A|CLK|X|clknet_2_1__leaf_clk \$983 VSS|gnd sg13_lv_nmos L=0.13u
+ W=0.74u AS=0.317325p AD=0.2516p PS=1.805u PD=2.16u
M$1369 \$999 \$983 \$928 VSS|gnd sg13_lv_nmos L=0.13u W=0.42u AS=0.1428p
+ AD=0.12665p PS=1.52u PD=1.145u
M$1370 \$928 \$927 \$925 VSS|gnd sg13_lv_nmos L=0.13u W=0.74u AS=0.12665p
+ AD=0.3473p PS=1.145u PD=2.71u
M$1371 VSS|gnd \$933 \$932 VSS|gnd sg13_lv_nmos L=0.5u W=0.42u AS=0.1426p
+ AD=0.1428p PS=1.16u PD=1.52u
M$1372 A|X|net63 \$932 VSS|gnd VSS|gnd sg13_lv_nmos L=0.13u W=0.74u AS=0.2516p
+ AD=0.1426p PS=2.16u PD=1.16u
M$1373 \$784 \$786 \$859 VSS|gnd sg13_lv_nmos L=0.13u W=0.42u AS=0.1296p
+ AD=0.0798p PS=1.52u PD=0.8u
M$1374 \$859 \$873 \$816 VSS|gnd sg13_lv_nmos L=0.13u W=0.42u AS=0.0798p
+ AD=0.2373p PS=0.8u PD=1.97u
M$1375 VSS|gnd A|B1|X|net30 D|Y|_021_ VSS|gnd sg13_lv_nmos L=0.13u W=0.74u
+ AS=0.2516p AD=0.1406p PS=2.16u PD=1.12u
M$1376 D|Y|_021_ A1|Y|_056_ \$1019 VSS|gnd sg13_lv_nmos L=0.13u W=0.74u
+ AS=0.1406p AD=0.1406p PS=1.12u PD=1.12u
M$1377 \$1019 A2|Y|_057_ VSS|gnd VSS|gnd sg13_lv_nmos L=0.13u W=0.74u
+ AS=0.1406p AD=0.2516p PS=1.12u PD=2.16u
M$1378 VSS|gnd \$786 \$873 VSS|gnd sg13_lv_nmos L=0.13u W=0.74u AS=0.317325p
+ AD=0.2516p PS=1.805u PD=2.16u
M$1379 VSS|gnd A|CLK|X|clknet_2_3__leaf_clk \$786 VSS|gnd sg13_lv_nmos L=0.13u
+ W=0.74u AS=0.317325p AD=0.2516p PS=1.805u PD=2.16u
M$1380 \$936 \$985 \$938 VSS|gnd sg13_lv_nmos L=0.13u W=0.42u AS=0.1296p
+ AD=0.0798p PS=1.52u PD=0.8u
M$1381 \$938 \$939 \$984 VSS|gnd sg13_lv_nmos L=0.13u W=0.42u AS=0.0798p
+ AD=0.2373p PS=0.8u PD=1.97u
M$1382 \$939 \$985 VSS|gnd VSS|gnd sg13_lv_nmos L=0.13u W=0.74u AS=0.2516p
+ AD=0.317325p PS=2.16u PD=1.805u
M$1383 VSS|gnd A|CLK|X|clknet_2_3__leaf_clk \$985 VSS|gnd sg13_lv_nmos L=0.13u
+ W=0.74u AS=0.317325p AD=0.2516p PS=1.805u PD=2.16u
M$1384 \$1000 \$985 \$940 VSS|gnd sg13_lv_nmos L=0.13u W=0.42u AS=0.1428p
+ AD=0.12665p PS=1.52u PD=1.145u
M$1385 \$940 \$939 \$937 VSS|gnd sg13_lv_nmos L=0.13u W=0.74u AS=0.12665p
+ AD=0.3473p PS=1.145u PD=2.71u
M$1386 VSS|gnd A2|Y|_041_ \$844 VSS|gnd sg13_lv_nmos L=0.13u W=0.74u AS=0.2516p
+ AD=0.1406p PS=2.16u PD=1.12u
M$1387 \$844 A1|A2|Y|_039_ D|Y|_005_ VSS|gnd sg13_lv_nmos L=0.13u W=0.74u
+ AS=0.1406p AD=0.1406p PS=1.12u PD=1.12u
M$1388 D|Y|_005_ A|B1|X|net31 VSS|gnd VSS|gnd sg13_lv_nmos L=0.13u W=0.74u
+ AS=0.1406p AD=0.2516p PS=1.12u PD=2.16u
M$1389 VSS|gnd A1|A2|Y|_039_ \$842 VSS|gnd sg13_lv_nmos L=0.13u W=0.74u
+ AS=0.2516p AD=0.1406p PS=2.16u PD=1.12u
M$1390 \$842 A1|Y|_063_ D|Y|_012_ VSS|gnd sg13_lv_nmos L=0.13u W=0.74u
+ AS=0.1406p AD=0.1406p PS=1.12u PD=1.12u
M$1391 D|Y|_012_ A|B1|X|net30 VSS|gnd VSS|gnd sg13_lv_nmos L=0.13u W=0.74u
+ AS=0.1406p AD=0.2516p PS=1.12u PD=2.16u
M$1392 \$944 \$988 \$946 VSS|gnd sg13_lv_nmos L=0.13u W=0.42u AS=0.1296p
+ AD=0.0798p PS=1.52u PD=0.8u
M$1393 \$946 \$947 \$987 VSS|gnd sg13_lv_nmos L=0.13u W=0.42u AS=0.0798p
+ AD=0.2373p PS=0.8u PD=1.97u
M$1394 \$947 \$988 VSS|gnd VSS|gnd sg13_lv_nmos L=0.13u W=0.74u AS=0.2516p
+ AD=0.317325p PS=2.16u PD=1.805u
M$1395 VSS|gnd A|CLK|X|clknet_2_3__leaf_clk \$988 VSS|gnd sg13_lv_nmos L=0.13u
+ W=0.74u AS=0.317325p AD=0.2516p PS=1.805u PD=2.16u
M$1396 \$1001 \$988 \$948 VSS|gnd sg13_lv_nmos L=0.13u W=0.42u AS=0.1428p
+ AD=0.12665p PS=1.52u PD=1.145u
M$1397 \$948 \$947 \$945 VSS|gnd sg13_lv_nmos L=0.13u W=0.74u AS=0.12665p
+ AD=0.3473p PS=1.145u PD=2.71u
M$1398 \$790 \$792 \$863 VSS|gnd sg13_lv_nmos L=0.13u W=0.42u AS=0.1296p
+ AD=0.0798p PS=1.52u PD=0.8u
M$1399 \$863 \$876 \$823 VSS|gnd sg13_lv_nmos L=0.13u W=0.42u AS=0.0798p
+ AD=0.2373p PS=0.8u PD=1.97u
M$1400 VSS|gnd \$792 \$876 VSS|gnd sg13_lv_nmos L=0.13u W=0.74u AS=0.317325p
+ AD=0.2516p PS=1.805u PD=2.16u
M$1401 VSS|gnd CLK|X|clknet_2_2__leaf_clk \$792 VSS|gnd sg13_lv_nmos L=0.13u
+ W=0.74u AS=0.317325p AD=0.2516p PS=1.805u PD=2.16u
M$1402 VSS|gnd \$953 \$952 VSS|gnd sg13_lv_nmos L=0.5u W=0.42u AS=0.1426p
+ AD=0.1428p PS=1.16u PD=1.52u
M$1403 A|X|net72 \$952 VSS|gnd VSS|gnd sg13_lv_nmos L=0.13u W=0.74u AS=0.2516p
+ AD=0.1426p PS=2.16u PD=1.16u
M$1404 VSS|gnd A|B1|X|net31 D|Y|_013_ VSS|gnd sg13_lv_nmos L=0.13u W=0.74u
+ AS=0.2516p AD=0.1406p PS=2.16u PD=1.12u
M$1405 D|Y|_013_ A1|Y|_062_ \$835 VSS|gnd sg13_lv_nmos L=0.13u W=0.74u
+ AS=0.1406p AD=0.1406p PS=1.12u PD=1.12u
M$1406 \$835 A1|A2|Y|_042_ VSS|gnd VSS|gnd sg13_lv_nmos L=0.13u W=0.74u
+ AS=0.1406p AD=0.2516p PS=1.12u PD=2.16u
M$1407 \$955 \$990 \$957 VSS|gnd sg13_lv_nmos L=0.13u W=0.42u AS=0.1296p
+ AD=0.0798p PS=1.52u PD=0.8u
M$1408 \$957 \$958 \$989 VSS|gnd sg13_lv_nmos L=0.13u W=0.42u AS=0.0798p
+ AD=0.2373p PS=0.8u PD=1.97u
M$1409 \$958 \$990 VSS|gnd VSS|gnd sg13_lv_nmos L=0.13u W=0.74u AS=0.2516p
+ AD=0.317325p PS=2.16u PD=1.805u
M$1410 VSS|gnd A|CLK|X|clknet_2_3__leaf_clk \$990 VSS|gnd sg13_lv_nmos L=0.13u
+ W=0.74u AS=0.317325p AD=0.2516p PS=1.805u PD=2.16u
M$1411 \$1002 \$990 \$959 VSS|gnd sg13_lv_nmos L=0.13u W=0.42u AS=0.1428p
+ AD=0.12665p PS=1.52u PD=1.145u
M$1412 \$959 \$958 \$956 VSS|gnd sg13_lv_nmos L=0.13u W=0.74u AS=0.12665p
+ AD=0.3473p PS=1.145u PD=2.71u
M$1413 \$797 \$799 \$867 VSS|gnd sg13_lv_nmos L=0.13u W=0.42u AS=0.1296p
+ AD=0.0798p PS=1.52u PD=0.8u
M$1414 \$867 \$878 \$826 VSS|gnd sg13_lv_nmos L=0.13u W=0.42u AS=0.0798p
+ AD=0.2373p PS=0.8u PD=1.97u
M$1415 VSS|gnd \$799 \$878 VSS|gnd sg13_lv_nmos L=0.13u W=0.74u AS=0.317325p
+ AD=0.2516p PS=1.805u PD=2.16u
M$1416 VSS|gnd A|CLK|X|clknet_2_3__leaf_clk \$799 VSS|gnd sg13_lv_nmos L=0.13u
+ W=0.74u AS=0.317325p AD=0.2516p PS=1.805u PD=2.16u
M$1417 VSS|gnd \$965 \$964 VSS|gnd sg13_lv_nmos L=0.5u W=0.42u AS=0.1426p
+ AD=0.1428p PS=1.16u PD=1.52u
M$1418 B_N|X|net59 \$964 VSS|gnd VSS|gnd sg13_lv_nmos L=0.13u W=0.74u
+ AS=0.2516p AD=0.1426p PS=2.16u PD=1.16u
M$1430 VSS|gnd L_HI|RESET_B|net45 \$1009 VSS|gnd sg13_lv_nmos L=0.13u W=0.42u
+ AS=0.1701p AD=0.0378p PS=1.65u PD=0.6u
M$1431 \$1009 \$907 \$974 VSS|gnd sg13_lv_nmos L=0.13u W=0.42u AS=0.0378p
+ AD=0.1428p PS=0.6u PD=1.52u
M$1432 \$912 \$910 VSS|gnd VSS|gnd sg13_lv_nmos L=0.13u W=0.74u AS=0.2516p
+ AD=0.1406p PS=2.16u PD=1.12u
M$1433 VSS|gnd \$912 A|Q|net20 VSS|gnd sg13_lv_nmos L=0.13u W=0.74u AS=0.1406p
+ AD=0.2516p PS=1.12u PD=2.16u
M$1435 A|Q|net10 \$919 VSS|gnd VSS|gnd sg13_lv_nmos L=0.13u W=0.74u AS=0.2516p
+ AD=0.1406p PS=2.16u PD=1.12u
M$1436 VSS|gnd \$978 \$919 VSS|gnd sg13_lv_nmos L=0.13u W=0.74u AS=0.1406p
+ AD=0.2516p PS=1.12u PD=2.16u
M$1437 \$980 \$981 \$1014 VSS|gnd sg13_lv_nmos L=0.13u W=0.42u AS=0.1428p
+ AD=0.0378p PS=1.52u PD=0.6u
M$1438 \$1014 L_HI|RESET_B|net34 VSS|gnd VSS|gnd sg13_lv_nmos L=0.13u W=0.42u
+ AS=0.0378p AD=0.1701p PS=0.6u PD=1.65u
M$1439 VSS|gnd L_HI|RESET_B|net41 \$1017 VSS|gnd sg13_lv_nmos L=0.13u W=0.42u
+ AS=0.1701p AD=0.0378p PS=1.65u PD=0.6u
M$1440 \$1017 \$925 \$982 VSS|gnd sg13_lv_nmos L=0.13u W=0.42u AS=0.0378p
+ AD=0.1428p PS=0.6u PD=1.52u
M$1441 \$930 \$928 VSS|gnd VSS|gnd sg13_lv_nmos L=0.13u W=0.74u AS=0.2516p
+ AD=0.1406p PS=2.16u PD=1.12u
M$1442 VSS|gnd \$930 A|Q|net22 VSS|gnd sg13_lv_nmos L=0.13u W=0.74u AS=0.1406p
+ AD=0.2516p PS=1.12u PD=2.16u
M$1443 VSS|gnd L_HI|RESET_B|net39 \$1021 VSS|gnd sg13_lv_nmos L=0.13u W=0.42u
+ AS=0.1701p AD=0.0378p PS=1.65u PD=0.6u
M$1444 \$1021 \$937 \$984 VSS|gnd sg13_lv_nmos L=0.13u W=0.42u AS=0.0378p
+ AD=0.1428p PS=0.6u PD=1.52u
M$1445 \$942 \$940 VSS|gnd VSS|gnd sg13_lv_nmos L=0.13u W=0.74u AS=0.2516p
+ AD=0.1406p PS=2.16u PD=1.12u
M$1446 VSS|gnd \$942 A|Q|net23 VSS|gnd sg13_lv_nmos L=0.13u W=0.74u AS=0.1406p
+ AD=0.2516p PS=1.12u PD=2.16u
M$1448 VSS|gnd L_HI|RESET_B|net37 \$1024 VSS|gnd sg13_lv_nmos L=0.13u W=0.42u
+ AS=0.1701p AD=0.0378p PS=1.65u PD=0.6u
M$1449 \$1024 \$945 \$987 VSS|gnd sg13_lv_nmos L=0.13u W=0.42u AS=0.0378p
+ AD=0.1428p PS=0.6u PD=1.52u
M$1450 \$950 \$948 VSS|gnd VSS|gnd sg13_lv_nmos L=0.13u W=0.74u AS=0.2516p
+ AD=0.1406p PS=2.16u PD=1.12u
M$1451 VSS|gnd \$950 A|Q|net24 VSS|gnd sg13_lv_nmos L=0.13u W=0.74u AS=0.1406p
+ AD=0.2516p PS=1.12u PD=2.16u
M$1453 VSS|gnd L_HI|RESET_B|net35 \$1027 VSS|gnd sg13_lv_nmos L=0.13u W=0.42u
+ AS=0.1701p AD=0.0378p PS=1.65u PD=0.6u
M$1454 \$1027 \$956 \$989 VSS|gnd sg13_lv_nmos L=0.13u W=0.42u AS=0.0378p
+ AD=0.1428p PS=0.6u PD=1.52u
M$1455 \$961 \$959 VSS|gnd VSS|gnd sg13_lv_nmos L=0.13u W=0.74u AS=0.2516p
+ AD=0.1406p PS=2.16u PD=1.12u
M$1456 VSS|gnd \$961 A|Q|net25 VSS|gnd sg13_lv_nmos L=0.13u W=0.74u AS=0.1406p
+ AD=0.2516p PS=1.12u PD=2.16u
M$1468 BN[5]|X \$1069 VSS|gnd VSS|gnd sg13_lv_nmos L=0.13u W=0.74u AS=0.2886p
+ AD=0.14875p PS=2.26u PD=1.16u
M$1469 VSS|gnd A|Q|net10 \$1069 VSS|gnd sg13_lv_nmos L=0.13u W=0.55u
+ AS=0.14875p AD=0.187p PS=1.16u PD=1.78u
M$1470 BN[6]|X \$1070 VSS|gnd VSS|gnd sg13_lv_nmos L=0.13u W=0.74u AS=0.2886p
+ AD=0.14875p PS=2.26u PD=1.16u
M$1471 VSS|gnd A|Q|net11 \$1070 VSS|gnd sg13_lv_nmos L=0.13u W=0.55u
+ AS=0.14875p AD=0.187p PS=1.16u PD=1.78u
M$1474 D[0]|X \$1071 VSS|gnd VSS|gnd sg13_lv_nmos L=0.13u W=0.74u AS=0.2886p
+ AD=0.14875p PS=2.26u PD=1.16u
M$1475 VSS|gnd A|Q|net19 \$1071 VSS|gnd sg13_lv_nmos L=0.13u W=0.55u
+ AS=0.14875p AD=0.187p PS=1.16u PD=1.78u
M$1483 VSS|gnd \$908 \$907 VSS|gnd sg13_lv_nmos L=0.13u W=0.74u AS=0.1626p
+ AD=0.2516p PS=1.415u PD=2.16u
M$1484 \$906 D|Y|_008_ \$1010 VSS|gnd sg13_lv_nmos L=0.13u W=0.42u AS=0.1428p
+ AD=0.0609p PS=1.52u PD=0.71u
M$1485 VSS|gnd L_HI|RESET_B|net45 \$1010 VSS|gnd sg13_lv_nmos L=0.13u W=0.42u
+ AS=0.1626p AD=0.0609p PS=1.415u PD=0.71u
M$1486 VSS|gnd \$1072 \$1032 VSS|gnd sg13_lv_nmos L=0.13u W=0.795u
+ AS=0.2043375p AD=0.274275p PS=1.585u PD=2.28u
M$1487 VSS|gnd \$1033 \$1033 VSS|gnd sg13_lv_nmos L=0.13u W=0.3u AS=0.2043375p
+ AD=0.111p PS=1.585u PD=1.34u
M$1489 D[1]|X \$1073 VSS|gnd VSS|gnd sg13_lv_nmos L=0.13u W=0.74u AS=0.2886p
+ AD=0.14875p PS=2.26u PD=1.16u
M$1490 VSS|gnd A|Q|net20 \$1073 VSS|gnd sg13_lv_nmos L=0.13u W=0.55u
+ AS=0.14875p AD=0.187p PS=1.16u PD=1.78u
M$1491 \$997 \$911 VSS|gnd VSS|gnd sg13_lv_nmos L=0.13u W=0.42u AS=0.1428p
+ AD=0.0798p PS=1.52u PD=0.8u
M$1492 VSS|gnd L_HI|RESET_B|net45 \$1011 VSS|gnd sg13_lv_nmos L=0.13u W=0.42u
+ AS=0.0798p AD=0.0378p PS=0.8u PD=0.6u
M$1493 \$1011 \$910 \$911 VSS|gnd sg13_lv_nmos L=0.13u W=0.42u AS=0.0378p
+ AD=0.1428p PS=0.6u PD=1.52u
M$1495 \$1035 A|Q|net20 VSS|gnd VSS|gnd sg13_lv_nmos L=0.13u W=0.42u AS=0.1428p
+ AD=0.0798p PS=1.52u PD=0.8u
M$1496 VSS|gnd \$1035 \$1036 VSS|gnd sg13_lv_nmos L=0.5u W=0.42u AS=0.0798p
+ AD=0.1428p PS=0.8u PD=1.52u
M$1497 \$915 \$916 VSS|gnd VSS|gnd sg13_lv_nmos L=0.5u W=0.42u AS=0.1428p
+ AD=0.0798p PS=1.52u PD=0.8u
M$1498 VSS|gnd A|Q|net19 \$916 VSS|gnd sg13_lv_nmos L=0.13u W=0.42u AS=0.0798p
+ AD=0.1428p PS=0.8u PD=1.52u
M$1499 VSS|gnd \$1036 \$1037 VSS|gnd sg13_lv_nmos L=0.5u W=0.42u AS=0.1426p
+ AD=0.1428p PS=1.16u PD=1.52u
M$1500 VSS|gnd \$1037 A|X|net65 VSS|gnd sg13_lv_nmos L=0.13u W=0.74u AS=0.1426p
+ AD=0.2516p PS=1.16u PD=2.16u
M$1501 VSS|gnd \$1074 \$1038 VSS|gnd sg13_lv_nmos L=0.13u W=0.795u
+ AS=0.2043375p AD=0.274275p PS=1.585u PD=2.28u
M$1502 VSS|gnd \$1039 \$1039 VSS|gnd sg13_lv_nmos L=0.13u W=0.3u AS=0.2043375p
+ AD=0.111p PS=1.585u PD=1.34u
M$1505 VSS|gnd A|Q|net21 \$1075 VSS|gnd sg13_lv_nmos L=0.13u W=0.55u
+ AS=0.14875p AD=0.187p PS=1.16u PD=1.78u
M$1506 VSS|gnd \$1075 D[2]|X VSS|gnd sg13_lv_nmos L=0.13u W=0.74u AS=0.14875p
+ AD=0.2886p PS=1.16u PD=2.26u
M$1507 \$920 \$978 \$1013 VSS|gnd sg13_lv_nmos L=0.13u W=0.42u AS=0.1428p
+ AD=0.0378p PS=1.52u PD=0.6u
M$1508 \$1013 L_HI|RESET_B|net34 VSS|gnd VSS|gnd sg13_lv_nmos L=0.13u W=0.42u
+ AS=0.0378p AD=0.0798p PS=0.6u PD=0.8u
M$1509 VSS|gnd \$920 \$998 VSS|gnd sg13_lv_nmos L=0.13u W=0.42u AS=0.0798p
+ AD=0.1428p PS=0.8u PD=1.52u
M$1510 A|X|net62 \$1076 VSS|gnd VSS|gnd sg13_lv_nmos L=0.13u W=0.74u AS=0.2516p
+ AD=0.1426p PS=2.16u PD=1.16u
M$1511 VSS|gnd \$1077 \$1076 VSS|gnd sg13_lv_nmos L=0.5u W=0.42u AS=0.1426p
+ AD=0.1428p PS=1.16u PD=1.52u
M$1512 \$1077 \$1041 VSS|gnd VSS|gnd sg13_lv_nmos L=0.5u W=0.42u AS=0.1428p
+ AD=0.0798p PS=1.52u PD=0.8u
M$1513 VSS|gnd A|Q|net21 \$1041 VSS|gnd sg13_lv_nmos L=0.13u W=0.42u AS=0.0798p
+ AD=0.1428p PS=0.8u PD=1.52u
M$1514 VSS|gnd \$1042 \$1042 VSS|gnd sg13_lv_nmos L=0.13u W=0.3u AS=0.2043375p
+ AD=0.111p PS=1.585u PD=1.34u
M$1515 VSS|gnd \$1078 \$1043 VSS|gnd sg13_lv_nmos L=0.13u W=0.795u
+ AS=0.2043375p AD=0.274275p PS=1.585u PD=2.28u
M$1520 VSS|gnd \$926 \$925 VSS|gnd sg13_lv_nmos L=0.13u W=0.74u AS=0.1626p
+ AD=0.2516p PS=1.415u PD=2.16u
M$1521 \$924 D|Y|_010_ \$1016 VSS|gnd sg13_lv_nmos L=0.13u W=0.42u AS=0.1428p
+ AD=0.0609p PS=1.52u PD=0.71u
M$1522 VSS|gnd L_HI|RESET_B|net41 \$1016 VSS|gnd sg13_lv_nmos L=0.13u W=0.42u
+ AS=0.1626p AD=0.0609p PS=1.415u PD=0.71u
M$1523 VSS|gnd \$1079 \$1044 VSS|gnd sg13_lv_nmos L=0.13u W=0.795u
+ AS=0.2043375p AD=0.274275p PS=1.585u PD=2.28u
M$1524 VSS|gnd \$1045 \$1045 VSS|gnd sg13_lv_nmos L=0.13u W=0.3u AS=0.2043375p
+ AD=0.111p PS=1.585u PD=1.34u
M$1527 D[3]|X \$1080 VSS|gnd VSS|gnd sg13_lv_nmos L=0.13u W=0.74u AS=0.2886p
+ AD=0.14875p PS=2.26u PD=1.16u
M$1528 VSS|gnd A|Q|net22 \$1080 VSS|gnd sg13_lv_nmos L=0.13u W=0.55u
+ AS=0.14875p AD=0.187p PS=1.16u PD=1.78u
M$1529 \$999 \$929 VSS|gnd VSS|gnd sg13_lv_nmos L=0.13u W=0.42u AS=0.1428p
+ AD=0.0798p PS=1.52u PD=0.8u
M$1530 VSS|gnd L_HI|RESET_B|net41 \$1018 VSS|gnd sg13_lv_nmos L=0.13u W=0.42u
+ AS=0.0798p AD=0.0378p PS=0.8u PD=0.6u
M$1531 \$1018 \$928 \$929 VSS|gnd sg13_lv_nmos L=0.13u W=0.42u AS=0.0378p
+ AD=0.1428p PS=0.6u PD=1.52u
M$1535 \$933 \$934 VSS|gnd VSS|gnd sg13_lv_nmos L=0.5u W=0.42u AS=0.1428p
+ AD=0.0798p PS=1.52u PD=0.8u
M$1536 VSS|gnd A|Q|net22 \$934 VSS|gnd sg13_lv_nmos L=0.13u W=0.42u AS=0.0798p
+ AD=0.1428p PS=0.8u PD=1.52u
M$1537 VSS|gnd \$1081 \$1047 VSS|gnd sg13_lv_nmos L=0.13u W=0.795u
+ AS=0.2043375p AD=0.274275p PS=1.585u PD=2.28u
M$1538 VSS|gnd \$1048 \$1048 VSS|gnd sg13_lv_nmos L=0.13u W=0.3u AS=0.2043375p
+ AD=0.111p PS=1.585u PD=1.34u
M$1541 VSS|gnd \$938 \$937 VSS|gnd sg13_lv_nmos L=0.13u W=0.74u AS=0.1626p
+ AD=0.2516p PS=1.415u PD=2.16u
M$1542 \$936 D|Y|_011_ \$1020 VSS|gnd sg13_lv_nmos L=0.13u W=0.42u AS=0.1428p
+ AD=0.0609p PS=1.52u PD=0.71u
M$1543 VSS|gnd L_HI|RESET_B|net39 \$1020 VSS|gnd sg13_lv_nmos L=0.13u W=0.42u
+ AS=0.1626p AD=0.0609p PS=1.415u PD=0.71u
M$1545 VSS|gnd \$1082 \$1049 VSS|gnd sg13_lv_nmos L=0.13u W=0.795u
+ AS=0.2043375p AD=0.274275p PS=1.585u PD=2.28u
M$1546 VSS|gnd \$1050 \$1050 VSS|gnd sg13_lv_nmos L=0.13u W=0.3u AS=0.2043375p
+ AD=0.111p PS=1.585u PD=1.34u
M$1548 D[4]|X \$1083 VSS|gnd VSS|gnd sg13_lv_nmos L=0.13u W=0.74u AS=0.2886p
+ AD=0.14875p PS=2.26u PD=1.16u
M$1549 VSS|gnd A|Q|net23 \$1083 VSS|gnd sg13_lv_nmos L=0.13u W=0.55u
+ AS=0.14875p AD=0.187p PS=1.16u PD=1.78u
M$1552 \$1000 \$941 VSS|gnd VSS|gnd sg13_lv_nmos L=0.13u W=0.42u AS=0.1428p
+ AD=0.0798p PS=1.52u PD=0.8u
M$1553 VSS|gnd L_HI|RESET_B|net39 \$1022 VSS|gnd sg13_lv_nmos L=0.13u W=0.42u
+ AS=0.0798p AD=0.0378p PS=0.8u PD=0.6u
M$1554 \$1022 \$940 \$941 VSS|gnd sg13_lv_nmos L=0.13u W=0.42u AS=0.0378p
+ AD=0.1428p PS=0.6u PD=1.52u
M$1557 VSS|gnd \$946 \$945 VSS|gnd sg13_lv_nmos L=0.13u W=0.74u AS=0.1626p
+ AD=0.2516p PS=1.415u PD=2.16u
M$1558 \$944 D|Y|_012_ \$1023 VSS|gnd sg13_lv_nmos L=0.13u W=0.42u AS=0.1428p
+ AD=0.0609p PS=1.52u PD=0.71u
M$1559 VSS|gnd L_HI|RESET_B|net37 \$1023 VSS|gnd sg13_lv_nmos L=0.13u W=0.42u
+ AS=0.1626p AD=0.0609p PS=1.415u PD=0.71u
M$1560 Y$1 A|CLK|X|clknet_2_3__leaf_clk VSS|gnd VSS|gnd sg13_lv_nmos L=0.13u
+ W=0.74u AS=0.2516p AD=0.2516p PS=2.16u PD=2.16u
M$1561 VSS|gnd \$1084 \$1053 VSS|gnd sg13_lv_nmos L=0.13u W=0.795u
+ AS=0.2043375p AD=0.274275p PS=1.585u PD=2.28u
M$1562 VSS|gnd \$1054 \$1054 VSS|gnd sg13_lv_nmos L=0.13u W=0.3u AS=0.2043375p
+ AD=0.111p PS=1.585u PD=1.34u
M$1563 A1|Y|_063_ A|X|net64 VSS|gnd VSS|gnd sg13_lv_nmos L=0.13u W=0.74u
+ AS=0.2516p AD=0.2516p PS=2.16u PD=2.16u
M$1564 VSS|gnd \$1086 \$1055 VSS|gnd sg13_lv_nmos L=0.13u W=0.795u
+ AS=0.2043375p AD=0.274275p PS=1.585u PD=2.28u
M$1565 VSS|gnd \$1056 \$1056 VSS|gnd sg13_lv_nmos L=0.13u W=0.3u AS=0.2043375p
+ AD=0.111p PS=1.585u PD=1.34u
M$1566 \$1001 \$949 VSS|gnd VSS|gnd sg13_lv_nmos L=0.13u W=0.42u AS=0.1428p
+ AD=0.0798p PS=1.52u PD=0.8u
M$1567 VSS|gnd L_HI|RESET_B|net37 \$1025 VSS|gnd sg13_lv_nmos L=0.13u W=0.42u
+ AS=0.0798p AD=0.0378p PS=0.8u PD=0.6u
M$1568 \$1025 \$948 \$949 VSS|gnd sg13_lv_nmos L=0.13u W=0.42u AS=0.0378p
+ AD=0.1428p PS=0.6u PD=1.52u
M$1569 A|X|net64 \$1087 VSS|gnd VSS|gnd sg13_lv_nmos L=0.13u W=0.74u AS=0.2516p
+ AD=0.1426p PS=2.16u PD=1.16u
M$1570 VSS|gnd \$1088 \$1087 VSS|gnd sg13_lv_nmos L=0.5u W=0.42u AS=0.1426p
+ AD=0.1428p PS=1.16u PD=1.52u
M$1571 \$1088 \$1057 VSS|gnd VSS|gnd sg13_lv_nmos L=0.5u W=0.42u AS=0.1428p
+ AD=0.0798p PS=1.52u PD=0.8u
M$1572 VSS|gnd A|Q|net24 \$1057 VSS|gnd sg13_lv_nmos L=0.13u W=0.42u AS=0.0798p
+ AD=0.1428p PS=0.8u PD=1.52u
M$1573 D[5]|X \$1089 VSS|gnd VSS|gnd sg13_lv_nmos L=0.13u W=0.74u AS=0.2886p
+ AD=0.14875p PS=2.26u PD=1.16u
M$1574 VSS|gnd A|Q|net24 \$1089 VSS|gnd sg13_lv_nmos L=0.13u W=0.55u
+ AS=0.14875p AD=0.187p PS=1.16u PD=1.78u
M$1575 \$953 \$954 VSS|gnd VSS|gnd sg13_lv_nmos L=0.5u W=0.42u AS=0.1428p
+ AD=0.0798p PS=1.52u PD=0.8u
M$1576 VSS|gnd A|Q|net17 \$954 VSS|gnd sg13_lv_nmos L=0.13u W=0.42u AS=0.0798p
+ AD=0.1428p PS=0.8u PD=1.52u
M$1581 VSS|gnd \$957 \$956 VSS|gnd sg13_lv_nmos L=0.13u W=0.74u AS=0.1626p
+ AD=0.2516p PS=1.415u PD=2.16u
M$1582 \$955 D|Y|_013_ \$1026 VSS|gnd sg13_lv_nmos L=0.13u W=0.42u AS=0.1428p
+ AD=0.0609p PS=1.52u PD=0.71u
M$1583 VSS|gnd L_HI|RESET_B|net35 \$1026 VSS|gnd sg13_lv_nmos L=0.13u W=0.42u
+ AS=0.1626p AD=0.0609p PS=1.415u PD=0.71u
M$1584 VSS|gnd \$1090 \$1059 VSS|gnd sg13_lv_nmos L=0.13u W=0.795u
+ AS=0.2043375p AD=0.274275p PS=1.585u PD=2.28u
M$1585 VSS|gnd \$1060 \$1060 VSS|gnd sg13_lv_nmos L=0.13u W=0.3u AS=0.2043375p
+ AD=0.111p PS=1.585u PD=1.34u
M$1586 VSS|gnd A|B1|X|net31 D|Y|_014_ VSS|gnd sg13_lv_nmos L=0.13u W=0.74u
+ AS=0.2516p AD=0.1406p PS=2.16u PD=1.12u
M$1587 D|Y|_014_ \$1091 VSS|gnd VSS|gnd sg13_lv_nmos L=0.13u W=0.74u AS=0.1406p
+ AD=0.17255p PS=1.12u PD=1.25u
M$1588 VSS|gnd B_N|X|net59 \$1091 VSS|gnd sg13_lv_nmos L=0.13u W=0.55u
+ AS=0.17255p AD=0.187p PS=1.25u PD=1.78u
M$1589 A1|Y|_062_ A|X|net61 VSS|gnd VSS|gnd sg13_lv_nmos L=0.13u W=0.74u
+ AS=0.2516p AD=0.2516p PS=2.16u PD=2.16u
M$1590 VSS|gnd \$1093 \$1061 VSS|gnd sg13_lv_nmos L=0.13u W=0.795u
+ AS=0.2043375p AD=0.274275p PS=1.585u PD=2.28u
M$1591 VSS|gnd \$1062 \$1062 VSS|gnd sg13_lv_nmos L=0.13u W=0.3u AS=0.2043375p
+ AD=0.111p PS=1.585u PD=1.34u
M$1592 \$1002 \$960 VSS|gnd VSS|gnd sg13_lv_nmos L=0.13u W=0.42u AS=0.1428p
+ AD=0.0798p PS=1.52u PD=0.8u
M$1593 VSS|gnd L_HI|RESET_B|net35 \$1028 VSS|gnd sg13_lv_nmos L=0.13u W=0.42u
+ AS=0.0798p AD=0.0378p PS=0.8u PD=0.6u
M$1594 \$1028 \$959 \$960 VSS|gnd sg13_lv_nmos L=0.13u W=0.42u AS=0.0378p
+ AD=0.1428p PS=0.6u PD=1.52u
M$1595 A|X|net61 \$1063 VSS|gnd VSS|gnd sg13_lv_nmos L=0.13u W=0.74u AS=0.2516p
+ AD=0.1426p PS=2.16u PD=1.16u
M$1596 VSS|gnd \$1094 \$1063 VSS|gnd sg13_lv_nmos L=0.5u W=0.42u AS=0.1426p
+ AD=0.1428p PS=1.16u PD=1.52u
M$1597 \$1094 \$1064 VSS|gnd VSS|gnd sg13_lv_nmos L=0.5u W=0.42u AS=0.1428p
+ AD=0.0798p PS=1.52u PD=0.8u
M$1598 VSS|gnd A|Q|net25 \$1064 VSS|gnd sg13_lv_nmos L=0.13u W=0.42u AS=0.0798p
+ AD=0.1428p PS=0.8u PD=1.52u
M$1599 D[6]|X \$1095 VSS|gnd VSS|gnd sg13_lv_nmos L=0.13u W=0.74u AS=0.2886p
+ AD=0.14875p PS=2.26u PD=1.16u
M$1600 VSS|gnd A|Q|net25 \$1095 VSS|gnd sg13_lv_nmos L=0.13u W=0.55u
+ AS=0.14875p AD=0.187p PS=1.16u PD=1.78u
M$1601 \$965 \$966 VSS|gnd VSS|gnd sg13_lv_nmos L=0.5u W=0.42u AS=0.1428p
+ AD=0.0798p PS=1.52u PD=0.8u
M$1602 VSS|gnd A|Q|net26 \$966 VSS|gnd sg13_lv_nmos L=0.13u W=0.42u AS=0.0798p
+ AD=0.1428p PS=0.8u PD=1.52u
M$1611 D[7]|X \$1096 VSS|gnd VSS|gnd sg13_lv_nmos L=0.13u W=0.74u AS=0.2886p
+ AD=0.14875p PS=2.26u PD=1.16u
M$1612 VSS|gnd A|Q|net26 \$1096 VSS|gnd sg13_lv_nmos L=0.13u W=0.55u
+ AS=0.14875p AD=0.187p PS=1.16u PD=1.78u
M$1613 VSS|gnd A|Q|net18 \$1097 VSS|gnd sg13_lv_nmos L=0.13u W=0.55u
+ AS=0.14875p AD=0.187p PS=1.16u PD=1.78u
M$1614 VSS|gnd \$1097 B[6]|X VSS|gnd sg13_lv_nmos L=0.13u W=0.74u AS=0.14875p
+ AD=0.2886p PS=1.16u PD=2.26u
M$1615 VSS|gnd A|Q|net17 \$1098 VSS|gnd sg13_lv_nmos L=0.13u W=0.55u
+ AS=0.14875p AD=0.187p PS=1.16u PD=1.78u
M$1616 VSS|gnd \$1098 B[5]|X VSS|gnd sg13_lv_nmos L=0.13u W=0.74u AS=0.14875p
+ AD=0.2886p PS=1.16u PD=2.26u
M$1617 VSS|gnd A|B1|X|net29 D|Y|_008_ VSS|gnd sg13_lv_nmos L=0.13u W=0.74u
+ AS=0.2516p AD=0.1406p PS=2.16u PD=1.12u
M$1618 D|Y|_008_ A1|Y|_066_ \$1099 VSS|gnd sg13_lv_nmos L=0.13u W=0.74u
+ AS=0.1406p AD=0.1406p PS=1.12u PD=1.12u
M$1619 \$1099 A1|A2|Y|_099_ VSS|gnd VSS|gnd sg13_lv_nmos L=0.13u W=0.74u
+ AS=0.1406p AD=0.2516p PS=1.12u PD=2.16u
M$1620 BN[0]|X \$19 VDD|vdd VDD|vdd sg13_lv_pmos L=0.13u W=1.12u AS=0.42p
+ AD=0.2114p PS=2.99u PD=1.54u
M$1621 VDD|vdd A|Q|net5 \$19 VDD|vdd sg13_lv_pmos L=0.13u W=0.84u AS=0.2114p
+ AD=0.2856p PS=1.54u PD=2.36u
M$1622 VDD|vdd A|Op \$20 VDD|vdd sg13_lv_pmos L=0.13u W=0.84u AS=0.2114p
+ AD=0.2856p PS=1.54u PD=2.36u
M$1623 VDD|vdd \$20 A|A1|X|net3 VDD|vdd sg13_lv_pmos L=0.13u W=1.12u AS=0.2114p
+ AD=0.42p PS=1.54u PD=2.99u
M$1624 D|Y|_016_ A|B1|X|net29 \$51 VDD|vdd sg13_lv_pmos L=0.13u W=1.12u
+ AS=0.3808p AD=0.2128p PS=2.92u PD=1.5u
M$1625 \$51 A1|Y|_047_ VDD|vdd VDD|vdd sg13_lv_pmos L=0.13u W=1.12u AS=0.2128p
+ AD=0.2128p PS=1.5u PD=1.5u
M$1626 VDD|vdd A2|Y|_049_ \$51 VDD|vdd sg13_lv_pmos L=0.13u W=1.12u AS=0.2128p
+ AD=0.3808p PS=1.5u PD=2.92u
M$1627 VDD|vdd A|X|net71 A1|Y|_047_ VDD|vdd sg13_lv_pmos L=0.13u W=1.12u
+ AS=0.3808p AD=0.2128p PS=2.92u PD=1.5u
M$1628 A1|Y|_047_ B|Y|_100_ VDD|vdd VDD|vdd sg13_lv_pmos L=0.13u W=1.12u
+ AS=0.2128p AD=0.3808p PS=1.5u PD=2.92u
M$1629 VDD|vdd B_N|Y|_089_ \$27 VDD|vdd sg13_lv_pmos L=0.13u W=0.84u AS=0.2618p
+ AD=0.2856p PS=1.63u PD=2.36u
M$1630 A2|B|Y|_090_ A|Y|_088_ \$62 VDD|vdd sg13_lv_pmos L=0.13u W=1.12u
+ AS=0.3808p AD=0.1176p PS=2.92u PD=1.33u
M$1631 \$62 \$27 VDD|vdd VDD|vdd sg13_lv_pmos L=0.13u W=1.12u AS=0.1176p
+ AD=0.2618p PS=1.33u PD=1.63u
M$1632 \$52 A|A2|X|net2 VDD|vdd VDD|vdd sg13_lv_pmos L=0.13u W=1.12u AS=0.3808p
+ AD=0.2128p PS=2.92u PD=1.5u
M$1633 VDD|vdd A|A1|X|net33 \$52 VDD|vdd sg13_lv_pmos L=0.13u W=1.12u
+ AS=0.2128p AD=0.2128p PS=1.5u PD=1.5u
M$1634 \$52 A|A1|B1|C|Q|counter\[3\] B_N|Y|_089_ VDD|vdd sg13_lv_pmos L=0.13u
+ W=1.12u AS=0.2128p AD=0.3808p PS=1.5u PD=2.92u
M$1635 VDD|vdd B_N|X|net83 \$30 VDD|vdd sg13_lv_pmos L=0.13u W=0.84u AS=0.2618p
+ AD=0.2856p PS=1.63u PD=2.36u
M$1636 D|Y|_025_ A|B1|X|net32 \$63 VDD|vdd sg13_lv_pmos L=0.13u W=1.12u
+ AS=0.3808p AD=0.1176p PS=2.92u PD=1.33u
M$1637 \$63 \$30 VDD|vdd VDD|vdd sg13_lv_pmos L=0.13u W=1.12u AS=0.1176p
+ AD=0.2618p PS=1.33u PD=1.63u
M$1638 B1|X|net1 \$35 VDD|vdd VDD|vdd sg13_lv_pmos L=0.13u W=1.12u AS=0.42p
+ AD=0.2114p PS=2.99u PD=1.54u
M$1639 VDD|vdd A|En \$35 VDD|vdd sg13_lv_pmos L=0.13u W=0.84u AS=0.2114p
+ AD=0.2856p PS=1.54u PD=2.36u
M$1640 VDD|vdd \$15 \$36 VDD|vdd sg13_lv_pmos L=0.5u W=1u AS=0.2254p AD=0.34p
+ PS=1.53u PD=2.68u
M$1641 B_N|X|net83 \$36 VDD|vdd VDD|vdd sg13_lv_pmos L=0.13u W=1.12u AS=0.4256p
+ AD=0.2254p PS=3u PD=1.53u
M$1642 \$53 A2|Y|_101_ VDD|vdd VDD|vdd sg13_lv_pmos L=0.13u W=1.12u AS=0.3808p
+ AD=0.2128p PS=2.92u PD=1.5u
M$1643 VDD|vdd A1|A2|Y|_099_ \$53 VDD|vdd sg13_lv_pmos L=0.13u W=1.12u
+ AS=0.2128p AD=0.2128p PS=1.5u PD=1.5u
M$1644 \$53 A|B1|X|net30 D|Y|_001_ VDD|vdd sg13_lv_pmos L=0.13u W=1.12u
+ AS=0.2128p AD=0.3808p PS=1.5u PD=2.92u
M$1645 A|X|net4 \$42 VDD|vdd VDD|vdd sg13_lv_pmos L=0.13u W=1.12u AS=0.42p
+ AD=0.2114p PS=2.99u PD=1.54u
M$1646 VDD|vdd A|rst \$42 VDD|vdd sg13_lv_pmos L=0.13u W=0.84u AS=0.2114p
+ AD=0.2856p PS=1.54u PD=2.36u
M$1647 A|A2|X|net2 \$43 VDD|vdd VDD|vdd sg13_lv_pmos L=0.13u W=1.12u AS=0.42p
+ AD=0.2114p PS=2.99u PD=1.54u
M$1648 VDD|vdd A|Om \$43 VDD|vdd sg13_lv_pmos L=0.13u W=0.84u AS=0.2114p
+ AD=0.2856p PS=1.54u PD=2.36u
M$1649 VDD|vdd A|Q|net12 \$44 VDD|vdd sg13_lv_pmos L=0.13u W=0.84u AS=0.2114p
+ AD=0.2856p PS=1.54u PD=2.36u
M$1650 VDD|vdd \$44 B[0]|X VDD|vdd sg13_lv_pmos L=0.13u W=1.12u AS=0.2114p
+ AD=0.42p PS=1.54u PD=2.99u
M$1651 VDD|vdd VSS|gnd VDD|vdd VDD|vdd sg13_lv_pmos L=1u W=575u AS=156.05p
+ AD=156.05p PS=1199.1u PD=1199.1u
M$1683 VDD|vdd \$34 \$33 VDD|vdd sg13_lv_pmos L=0.13u W=0.66u AS=0.4657125p
+ AD=0.2442p PS=2.54u PD=2.06u
M$1684 L_HI|RESET_B|net56 \$32 VDD|vdd VDD|vdd sg13_lv_pmos L=0.13u W=1.155u
+ AS=0.3927p AD=0.4657125p PS=2.99u PD=2.54u
M$1685 VDD|vdd A|A1|B1|C|Q|counter\[3\] \$16 VDD|vdd sg13_lv_pmos L=0.13u
+ W=0.42u AS=0.1523p AD=0.1428p PS=1.38u PD=1.52u
M$1686 \$15 \$16 VDD|vdd VDD|vdd sg13_lv_pmos L=0.5u W=1u AS=0.34p AD=0.1523p
+ PS=2.68u PD=1.38u
M$1687 VDD|vdd \$41 \$40 VDD|vdd sg13_lv_pmos L=0.13u W=0.66u AS=0.4657125p
+ AD=0.2442p PS=2.54u PD=2.06u
M$1688 L_HI|RESET_B|net \$39 VDD|vdd VDD|vdd sg13_lv_pmos L=0.13u W=1.155u
+ AS=0.3927p AD=0.4657125p PS=2.99u PD=2.54u
M$1721 VDD|vdd A|Q|net6 \$71 VDD|vdd sg13_lv_pmos L=0.13u W=0.84u AS=0.2114p
+ AD=0.2856p PS=1.54u PD=2.36u
M$1722 BN[1]|X \$71 VDD|vdd VDD|vdd sg13_lv_pmos L=0.13u W=1.12u AS=0.42p
+ AD=0.2114p PS=2.99u PD=1.54u
M$1752 VDD|vdd D|Y|_016_ \$72 VDD|vdd sg13_lv_pmos L=0.13u W=0.42u AS=0.1428p
+ AD=0.0798p PS=1.52u PD=0.8u
M$1753 VDD|vdd L_HI|RESET_B|net50 \$72 VDD|vdd sg13_lv_pmos L=0.13u W=0.42u
+ AS=0.3623875p AD=0.0798p PS=2.605u PD=0.8u
M$1754 VDD|vdd \$73 \$74 VDD|vdd sg13_lv_pmos L=0.13u W=1u AS=0.3623875p
+ AD=0.34p PS=2.605u PD=2.68u
M$1755 VDD|vdd \$76 \$75 VDD|vdd sg13_lv_pmos L=0.13u W=1.12u AS=0.41165p
+ AD=0.3864p PS=2.12u PD=2.93u
M$1756 VDD|vdd CLK|X|clknet_2_0__leaf_clk \$76 VDD|vdd sg13_lv_pmos L=0.13u
+ W=1.12u AS=0.41165p AD=0.4088p PS=2.12u PD=2.97u
M$1757 \$74 \$76 \$77 VDD|vdd sg13_lv_pmos L=0.13u W=1u AS=0.34p AD=0.2048p
+ PS=2.68u PD=1.63u
M$1758 \$77 \$75 \$102 VDD|vdd sg13_lv_pmos L=0.13u W=0.42u AS=0.2048p
+ AD=0.09345p PS=1.63u PD=0.865u
M$1759 VDD|vdd \$78 \$102 VDD|vdd sg13_lv_pmos L=0.13u W=0.42u AS=0.204p
+ AD=0.09345p PS=1.835u PD=0.865u
M$1760 VDD|vdd L_HI|RESET_B|net50 \$78 VDD|vdd sg13_lv_pmos L=0.13u W=0.42u
+ AS=0.204p AD=0.0798p PS=1.835u PD=0.8u
M$1761 VDD|vdd \$77 \$78 VDD|vdd sg13_lv_pmos L=0.13u W=0.42u AS=0.4659p
+ AD=0.0798p PS=3.65u PD=0.8u
M$1762 \$79 \$77 VDD|vdd VDD|vdd sg13_lv_pmos L=0.13u W=1.12u AS=0.3864p
+ AD=0.2128p PS=2.93u PD=1.5u
M$1763 VDD|vdd \$79 A|Q|net6 VDD|vdd sg13_lv_pmos L=0.13u W=1.12u AS=0.2128p
+ AD=0.3808p PS=1.5u PD=2.92u
M$1764 A|X|net71 \$80 VDD|vdd VDD|vdd sg13_lv_pmos L=0.13u W=1.12u AS=0.4256p
+ AD=0.2254p PS=3u PD=1.53u
M$1765 VDD|vdd \$81 \$80 VDD|vdd sg13_lv_pmos L=0.5u W=1u AS=0.2254p AD=0.34p
+ PS=1.53u PD=2.68u
M$1766 VDD|vdd A|Q|net6 \$82 VDD|vdd sg13_lv_pmos L=0.13u W=0.42u AS=0.1523p
+ AD=0.1428p PS=1.38u PD=1.52u
M$1767 \$81 \$82 VDD|vdd VDD|vdd sg13_lv_pmos L=0.5u W=1u AS=0.34p AD=0.1523p
+ PS=2.68u PD=1.38u
M$1768 VDD|vdd D|Y|_025_ \$83 VDD|vdd sg13_lv_pmos L=0.13u W=0.42u AS=0.1428p
+ AD=0.0798p PS=1.52u PD=0.8u
M$1769 VDD|vdd L_HI|RESET_B|net56 \$83 VDD|vdd sg13_lv_pmos L=0.13u W=0.42u
+ AS=0.3623875p AD=0.0798p PS=2.605u PD=0.8u
M$1770 VDD|vdd \$84 \$85 VDD|vdd sg13_lv_pmos L=0.13u W=1u AS=0.3623875p
+ AD=0.34p PS=2.605u PD=2.68u
M$1771 VDD|vdd \$87 \$86 VDD|vdd sg13_lv_pmos L=0.13u W=1.12u AS=0.41165p
+ AD=0.3864p PS=2.12u PD=2.93u
M$1772 VDD|vdd CLK|X|clknet_2_2__leaf_clk \$87 VDD|vdd sg13_lv_pmos L=0.13u
+ W=1.12u AS=0.41165p AD=0.4088p PS=2.12u PD=2.97u
M$1773 \$85 \$87 \$88 VDD|vdd sg13_lv_pmos L=0.13u W=1u AS=0.34p AD=0.2048p
+ PS=2.68u PD=1.63u
M$1774 \$88 \$86 \$104 VDD|vdd sg13_lv_pmos L=0.13u W=0.42u AS=0.2048p
+ AD=0.09345p PS=1.63u PD=0.865u
M$1775 VDD|vdd \$89 \$104 VDD|vdd sg13_lv_pmos L=0.13u W=0.42u AS=0.204p
+ AD=0.09345p PS=1.835u PD=0.865u
M$1776 VDD|vdd L_HI|RESET_B|net56 \$89 VDD|vdd sg13_lv_pmos L=0.13u W=0.42u
+ AS=0.204p AD=0.0798p PS=1.835u PD=0.8u
M$1777 VDD|vdd \$88 \$89 VDD|vdd sg13_lv_pmos L=0.13u W=0.42u AS=0.4659p
+ AD=0.0798p PS=3.65u PD=0.8u
M$1778 \$90 \$88 VDD|vdd VDD|vdd sg13_lv_pmos L=0.13u W=1.12u AS=0.3864p
+ AD=0.2128p PS=2.93u PD=1.5u
M$1779 VDD|vdd \$90 A|A1|B1|C|Q|counter\[3\] VDD|vdd sg13_lv_pmos L=0.13u
+ W=1.12u AS=0.2128p AD=0.3808p PS=1.5u PD=2.92u
M$1780 VDD|vdd D|Y|_001_ \$91 VDD|vdd sg13_lv_pmos L=0.13u W=0.42u AS=0.1428p
+ AD=0.0798p PS=1.52u PD=0.8u
M$1781 VDD|vdd L_HI|RESET_B|net \$91 VDD|vdd sg13_lv_pmos L=0.13u W=0.42u
+ AS=0.3623875p AD=0.0798p PS=2.605u PD=0.8u
M$1782 VDD|vdd \$92 \$93 VDD|vdd sg13_lv_pmos L=0.13u W=1u AS=0.3623875p
+ AD=0.34p PS=2.605u PD=2.68u
M$1783 VDD|vdd \$95 \$94 VDD|vdd sg13_lv_pmos L=0.13u W=1.12u AS=0.41165p
+ AD=0.3864p PS=2.12u PD=2.93u
M$1784 VDD|vdd CLK|X|clknet_2_2__leaf_clk \$95 VDD|vdd sg13_lv_pmos L=0.13u
+ W=1.12u AS=0.41165p AD=0.4088p PS=2.12u PD=2.97u
M$1785 \$93 \$95 \$96 VDD|vdd sg13_lv_pmos L=0.13u W=1u AS=0.34p AD=0.2048p
+ PS=2.68u PD=1.63u
M$1786 \$96 \$94 \$106 VDD|vdd sg13_lv_pmos L=0.13u W=0.42u AS=0.2048p
+ AD=0.09345p PS=1.63u PD=0.865u
M$1787 VDD|vdd \$97 \$106 VDD|vdd sg13_lv_pmos L=0.13u W=0.42u AS=0.204p
+ AD=0.09345p PS=1.835u PD=0.865u
M$1788 VDD|vdd L_HI|RESET_B|net \$97 VDD|vdd sg13_lv_pmos L=0.13u W=0.42u
+ AS=0.204p AD=0.0798p PS=1.835u PD=0.8u
M$1789 VDD|vdd \$96 \$97 VDD|vdd sg13_lv_pmos L=0.13u W=0.42u AS=0.4659p
+ AD=0.0798p PS=3.65u PD=0.8u
M$1790 \$98 \$96 VDD|vdd VDD|vdd sg13_lv_pmos L=0.13u W=1.12u AS=0.3864p
+ AD=0.2128p PS=2.93u PD=1.5u
M$1791 VDD|vdd \$98 A|Q|net13 VDD|vdd sg13_lv_pmos L=0.13u W=1.12u AS=0.2128p
+ AD=0.3808p PS=1.5u PD=2.92u
M$1822 \$100 A|Q|net13 VDD|vdd VDD|vdd sg13_lv_pmos L=0.13u W=0.84u AS=0.2856p
+ AD=0.2114p PS=2.36u PD=1.54u
M$1823 VDD|vdd \$100 B[1]|X VDD|vdd sg13_lv_pmos L=0.13u W=1.12u AS=0.2114p
+ AD=0.42p PS=1.54u PD=2.99u
M$1854 A|Y|_059_ B1|X|net84 \$147 VDD|vdd sg13_lv_pmos L=0.13u W=1.12u
+ AS=0.3808p AD=0.2128p PS=2.92u PD=1.5u
M$1855 \$147 A1|B|B1|C|X|net28 VDD|vdd VDD|vdd sg13_lv_pmos L=0.13u W=1.12u
+ AS=0.2128p AD=0.2128p PS=1.5u PD=1.5u
M$1856 VDD|vdd A2|B|Y|_090_ \$147 VDD|vdd sg13_lv_pmos L=0.13u W=1.12u
+ AS=0.2128p AD=0.3808p PS=1.5u PD=2.92u
M$1857 VDD|vdd L_HI|RESET_B|net50 \$73 VDD|vdd sg13_lv_pmos L=0.13u W=0.42u
+ AS=0.1563p AD=0.147p PS=1.22u PD=1.54u
M$1858 VDD|vdd \$74 \$101 VDD|vdd sg13_lv_pmos L=0.13u W=0.42u AS=0.1563p
+ AD=0.063p PS=1.22u PD=0.72u
M$1859 \$101 \$76 \$73 VDD|vdd sg13_lv_pmos L=0.13u W=0.42u AS=0.063p
+ AD=0.0798p PS=0.72u PD=0.8u
M$1860 \$73 \$75 \$72 VDD|vdd sg13_lv_pmos L=0.13u W=0.42u AS=0.0798p
+ AD=0.1428p PS=0.8u PD=1.52u
M$1861 VDD|vdd \$134 \$133 VDD|vdd sg13_lv_pmos L=0.13u W=0.66u AS=0.4657125p
+ AD=0.2442p PS=2.54u PD=2.06u
M$1862 L_HI|RESET_B|net50 \$132 VDD|vdd VDD|vdd sg13_lv_pmos L=0.13u W=1.155u
+ AS=0.3927p AD=0.4657125p PS=2.99u PD=2.54u
M$1863 VDD|vdd A|B1|X|net32 \$135 VDD|vdd sg13_lv_pmos L=0.13u W=0.84u
+ AS=0.2114p AD=0.2856p PS=1.54u PD=2.36u
M$1864 VDD|vdd \$135 A|B1|X|net29 VDD|vdd sg13_lv_pmos L=0.13u W=1.12u
+ AS=0.2114p AD=0.42p PS=1.54u PD=2.99u
M$1865 A1|B|B1|C|X|net28 \$137 VDD|vdd VDD|vdd sg13_lv_pmos L=0.13u W=1.12u
+ AS=0.42p AD=0.2114p PS=2.99u PD=1.54u
M$1866 VDD|vdd A|X|net86 \$137 VDD|vdd sg13_lv_pmos L=0.13u W=0.84u AS=0.2114p
+ AD=0.2856p PS=1.54u PD=2.36u
M$1873 VDD|vdd B1|X|net1 A|Y|_088_ VDD|vdd sg13_lv_pmos L=0.15u W=1.12u
+ AS=0.3808p AD=0.2128p PS=2.92u PD=1.5u
M$1874 A|Y|_088_ A|A2|X|net2 \$154 VDD|vdd sg13_lv_pmos L=0.15u W=1.12u
+ AS=0.2128p AD=0.2128p PS=1.5u PD=1.5u
M$1875 \$154 A|A1|X|net33 VDD|vdd VDD|vdd sg13_lv_pmos L=0.15u W=1.12u
+ AS=0.2128p AD=0.3808p PS=1.5u PD=2.92u
M$1876 VDD|vdd L_HI|RESET_B|net56 \$84 VDD|vdd sg13_lv_pmos L=0.13u W=0.42u
+ AS=0.1563p AD=0.147p PS=1.22u PD=1.54u
M$1877 VDD|vdd \$85 \$103 VDD|vdd sg13_lv_pmos L=0.13u W=0.42u AS=0.1563p
+ AD=0.063p PS=1.22u PD=0.72u
M$1878 \$103 \$87 \$84 VDD|vdd sg13_lv_pmos L=0.13u W=0.42u AS=0.063p
+ AD=0.0798p PS=0.72u PD=0.8u
M$1879 \$84 \$86 \$83 VDD|vdd sg13_lv_pmos L=0.13u W=0.42u AS=0.0798p
+ AD=0.1428p PS=0.8u PD=1.52u
M$1885 VDD|vdd B|Y|_100_ A2|Y|_101_ VDD|vdd sg13_lv_pmos L=0.13u W=1.12u
+ AS=0.3808p AD=0.2128p PS=2.92u PD=1.5u
M$1886 A2|Y|_101_ A|X|net75 VDD|vdd VDD|vdd sg13_lv_pmos L=0.13u W=1.12u
+ AS=0.2128p AD=0.3808p PS=1.5u PD=2.92u
M$1889 VDD|vdd L_HI|RESET_B|net \$92 VDD|vdd sg13_lv_pmos L=0.13u W=0.42u
+ AS=0.1563p AD=0.147p PS=1.22u PD=1.54u
M$1890 VDD|vdd \$93 \$105 VDD|vdd sg13_lv_pmos L=0.13u W=0.42u AS=0.1563p
+ AD=0.063p PS=1.22u PD=0.72u
M$1891 \$105 \$95 \$92 VDD|vdd sg13_lv_pmos L=0.13u W=0.42u AS=0.063p
+ AD=0.0798p PS=0.72u PD=0.8u
M$1892 \$92 \$94 \$91 VDD|vdd sg13_lv_pmos L=0.13u W=0.42u AS=0.0798p
+ AD=0.1428p PS=0.8u PD=1.52u
M$1894 VDD|vdd \$141 \$140 VDD|vdd sg13_lv_pmos L=0.5u W=1u AS=0.2254p AD=0.34p
+ PS=1.53u PD=2.68u
M$1895 A|X|net75 \$140 VDD|vdd VDD|vdd sg13_lv_pmos L=0.13u W=1.12u AS=0.4256p
+ AD=0.2254p PS=3u PD=1.53u
M$1896 VDD|vdd A|Q|net13 \$129 VDD|vdd sg13_lv_pmos L=0.13u W=0.42u AS=0.1523p
+ AD=0.1428p PS=1.38u PD=1.52u
M$1897 \$141 \$129 VDD|vdd VDD|vdd sg13_lv_pmos L=0.5u W=1u AS=0.34p AD=0.1523p
+ PS=2.68u PD=1.38u
M$1898 VDD|vdd \$144 \$143 VDD|vdd sg13_lv_pmos L=0.13u W=0.66u AS=0.4657125p
+ AD=0.2442p PS=2.54u PD=2.06u
M$1899 L_HI|RESET_B|net48 \$142 VDD|vdd VDD|vdd sg13_lv_pmos L=0.13u W=1.155u
+ AS=0.3927p AD=0.4657125p PS=2.99u PD=2.54u
M$1943 VDD|vdd \$205 \$158 VDD|vdd sg13_lv_pmos L=0.13u W=0.66u AS=0.4657125p
+ AD=0.2442p PS=2.54u PD=2.06u
M$1944 VDD|vdd \$198 L_HI|RESET_B|net46 VDD|vdd sg13_lv_pmos L=0.13u W=1.155u
+ AS=0.4657125p AD=0.3927p PS=2.54u PD=2.99u
M$1946 VDD|vdd A|Q|net7 \$160 VDD|vdd sg13_lv_pmos L=0.13u W=0.42u AS=0.1523p
+ AD=0.1428p PS=1.38u PD=1.52u
M$1947 VDD|vdd \$160 \$161 VDD|vdd sg13_lv_pmos L=0.5u W=1u AS=0.1523p AD=0.34p
+ PS=1.38u PD=2.68u
M$1948 VDD|vdd \$161 \$162 VDD|vdd sg13_lv_pmos L=0.5u W=1u AS=0.2254p AD=0.34p
+ PS=1.53u PD=2.68u
M$1949 VDD|vdd \$162 A1|X|net80 VDD|vdd sg13_lv_pmos L=0.13u W=1.12u AS=0.2254p
+ AD=0.4256p PS=1.53u PD=3u
M$1950 D|Y|_017_ A|Y|_050_ \$195 VDD|vdd sg13_lv_pmos L=0.13u W=1.12u
+ AS=0.3808p AD=0.1176p PS=2.92u PD=1.33u
M$1951 \$195 \$165 VDD|vdd VDD|vdd sg13_lv_pmos L=0.13u W=1.12u AS=0.1176p
+ AD=0.2618p PS=1.33u PD=1.63u
M$1952 VDD|vdd A1|A2|B_N|Y|_028_ \$165 VDD|vdd sg13_lv_pmos L=0.13u W=0.84u
+ AS=0.2618p AD=0.2856p PS=1.63u PD=2.36u
M$1958 VDD|vdd A|B|B1|Y|_068_ A|A2|Y|_034_ VDD|vdd sg13_lv_pmos L=0.13u W=1.12u
+ AS=0.3808p AD=0.2128p PS=2.92u PD=1.5u
M$1959 A|A2|Y|_034_ A2|B|Y|_032_ VDD|vdd VDD|vdd sg13_lv_pmos L=0.13u W=1.12u
+ AS=0.2128p AD=0.3808p PS=1.5u PD=2.92u
M$1960 B|X|net85 \$167 VDD|vdd VDD|vdd sg13_lv_pmos L=0.13u W=1.12u AS=0.4256p
+ AD=0.2254p PS=3u PD=1.53u
M$1961 VDD|vdd \$168 \$167 VDD|vdd sg13_lv_pmos L=0.5u W=1u AS=0.2254p AD=0.34p
+ PS=1.53u PD=2.68u
M$1962 VDD|vdd A|Y|_059_ \$169 VDD|vdd sg13_lv_pmos L=0.13u W=0.42u AS=0.1523p
+ AD=0.1428p PS=1.38u PD=1.52u
M$1963 \$168 \$169 VDD|vdd VDD|vdd sg13_lv_pmos L=0.5u W=1u AS=0.34p AD=0.1523p
+ PS=2.68u PD=1.38u
M$1964 \$170 A2|B|C|D|X|net27 VDD|vdd VDD|vdd sg13_lv_pmos L=0.13u W=1.12u
+ AS=0.3808p AD=0.2128p PS=2.92u PD=1.5u
M$1965 VDD|vdd A1|B|B1|C|X|net28 \$170 VDD|vdd sg13_lv_pmos L=0.13u W=1.12u
+ AS=0.2128p AD=0.2128p PS=1.5u PD=1.5u
M$1966 \$170 B1|Y|_058_ A|Y|_022_ VDD|vdd sg13_lv_pmos L=0.13u W=1.12u
+ AS=0.2128p AD=0.3808p PS=1.5u PD=2.92u
M$1967 VDD|vdd \$176 \$175 VDD|vdd sg13_lv_pmos L=0.13u W=1.12u AS=0.41165p
+ AD=0.3864p PS=2.12u PD=2.93u
M$1968 VDD|vdd CLK|X|clknet_2_0__leaf_clk \$176 VDD|vdd sg13_lv_pmos L=0.13u
+ W=1.12u AS=0.41165p AD=0.4088p PS=2.12u PD=2.97u
M$1969 \$179 \$177 VDD|vdd VDD|vdd sg13_lv_pmos L=0.13u W=1.12u AS=0.3864p
+ AD=0.2128p PS=2.93u PD=1.5u
M$1970 VDD|vdd \$179 A|A2|Q|counter\[0\] VDD|vdd sg13_lv_pmos L=0.13u W=1.12u
+ AS=0.2128p AD=0.3808p PS=1.5u PD=2.92u
M$1975 VDD|vdd A|A1|A_N|B|C|Q|counter\[1\] B1|D|Y|_069_ VDD|vdd sg13_lv_pmos
+ L=0.13u W=1.12u AS=0.3808p AD=0.2128p PS=2.92u PD=1.5u
M$1976 B1|D|Y|_069_ A|A1|B1|C|Q|counter\[3\] VDD|vdd VDD|vdd sg13_lv_pmos
+ L=0.13u W=1.12u AS=0.2128p AD=0.3808p PS=1.5u PD=2.92u
M$1977 B|C|Y|_074_ A|A1|B1|C|Q|counter\[3\] VDD|vdd VDD|vdd sg13_lv_pmos
+ L=0.13u W=1.12u AS=0.3808p AD=0.2128p PS=2.92u PD=1.5u
M$1978 VDD|vdd A1|B|B1|C|X|net28 B|C|Y|_074_ VDD|vdd sg13_lv_pmos L=0.13u
+ W=1.12u AS=0.2128p AD=0.2128p PS=1.5u PD=1.5u
M$1979 B|C|Y|_074_ A2|B|C|Y|_070_ VDD|vdd VDD|vdd sg13_lv_pmos L=0.13u W=1.12u
+ AS=0.2128p AD=0.3808p PS=1.5u PD=2.92u
M$1980 VDD|vdd A|A2|Q|counter\[0\] \$156 VDD|vdd sg13_lv_pmos L=0.13u W=1.12u
+ AS=0.3808p AD=0.2744p PS=2.92u PD=1.61u
M$1981 \$156 A|B|B2|Q|counter\[2\] B|Y|_084_ VDD|vdd sg13_lv_pmos L=0.13u
+ W=1.12u AS=0.2744p AD=0.2128p PS=1.61u PD=1.5u
M$1982 B|Y|_084_ B1|D|Y|_069_ \$156 VDD|vdd sg13_lv_pmos L=0.13u W=1.12u
+ AS=0.2128p AD=0.2716p PS=1.5u PD=1.605u
M$1983 \$156 A|A1|A_N|B|C|Q|counter\[1\] VDD|vdd VDD|vdd sg13_lv_pmos L=0.13u
+ W=1.12u AS=0.2716p AD=0.3808p PS=1.605u PD=2.92u
M$1984 A2|B|C|Y|_070_ A|A1|B1|C|Q|counter\[3\] VDD|vdd VDD|vdd sg13_lv_pmos
+ L=0.13u W=1.12u AS=0.3808p AD=0.2128p PS=2.92u PD=1.5u
M$1985 VDD|vdd A|B|B2|Q|counter\[2\] A2|B|C|Y|_070_ VDD|vdd sg13_lv_pmos
+ L=0.13u W=1.12u AS=0.2128p AD=0.2128p PS=1.5u PD=1.5u
M$1986 A2|B|C|Y|_070_ A|A1|A_N|B|C|Q|counter\[1\] VDD|vdd VDD|vdd sg13_lv_pmos
+ L=0.13u W=1.12u AS=0.2128p AD=0.3808p PS=1.5u PD=2.92u
M$1992 D|X|net79 \$187 VDD|vdd VDD|vdd sg13_lv_pmos L=0.13u W=1.12u AS=0.4256p
+ AD=0.2254p PS=3u PD=1.53u
M$1993 VDD|vdd \$188 \$187 VDD|vdd sg13_lv_pmos L=0.5u W=1u AS=0.2254p AD=0.34p
+ PS=1.53u PD=2.68u
M$1994 VDD|vdd A|Y|_024_ \$189 VDD|vdd sg13_lv_pmos L=0.13u W=0.42u AS=0.1523p
+ AD=0.1428p PS=1.38u PD=1.52u
M$1995 \$188 \$189 VDD|vdd VDD|vdd sg13_lv_pmos L=0.5u W=1u AS=0.34p AD=0.1523p
+ PS=2.68u PD=1.38u
M$1996 A|X|net78 \$190 VDD|vdd VDD|vdd sg13_lv_pmos L=0.13u W=1.12u AS=0.4256p
+ AD=0.2254p PS=3u PD=1.53u
M$1997 VDD|vdd \$191 \$190 VDD|vdd sg13_lv_pmos L=0.5u W=1u AS=0.2254p AD=0.34p
+ PS=1.53u PD=2.68u
M$1998 VDD|vdd A|B|B2|Q|counter\[2\] \$192 VDD|vdd sg13_lv_pmos L=0.13u W=0.42u
+ AS=0.1523p AD=0.1428p PS=1.38u PD=1.52u
M$1999 \$191 \$192 VDD|vdd VDD|vdd sg13_lv_pmos L=0.5u W=1u AS=0.34p AD=0.1523p
+ PS=2.68u PD=1.38u
M$2000 \$193 A2|Y|_029_ VDD|vdd VDD|vdd sg13_lv_pmos L=0.13u W=1.12u AS=0.3808p
+ AD=0.2128p PS=2.92u PD=1.5u
M$2001 VDD|vdd A1|A2|B_N|Y|_028_ \$193 VDD|vdd sg13_lv_pmos L=0.13u W=1.12u
+ AS=0.2128p AD=0.2128p PS=1.5u PD=1.5u
M$2002 \$193 A|B1|X|net30 D|Y|_002_ VDD|vdd sg13_lv_pmos L=0.13u W=1.12u
+ AS=0.2128p AD=0.3808p PS=1.5u PD=2.92u
M$2029 BN[2]|X \$261 VDD|vdd VDD|vdd sg13_lv_pmos L=0.13u W=1.12u AS=0.42p
+ AD=0.2114p PS=2.99u PD=1.54u
M$2030 VDD|vdd A|Q|net7 \$261 VDD|vdd sg13_lv_pmos L=0.13u W=0.84u AS=0.2114p
+ AD=0.2856p PS=1.54u PD=2.36u
M$2031 A|Q|net7 \$243 VDD|vdd VDD|vdd sg13_lv_pmos L=0.13u W=1.12u AS=0.3808p
+ AD=0.2128p PS=2.92u PD=1.5u
M$2032 VDD|vdd \$262 \$243 VDD|vdd sg13_lv_pmos L=0.13u W=1.12u AS=0.2128p
+ AD=0.3864p PS=1.5u PD=2.93u
M$2033 VDD|vdd \$262 \$244 VDD|vdd sg13_lv_pmos L=0.13u W=0.42u AS=0.4659p
+ AD=0.0798p PS=3.65u PD=0.8u
M$2034 \$244 L_HI|RESET_B|net46 VDD|vdd VDD|vdd sg13_lv_pmos L=0.13u W=0.42u
+ AS=0.0798p AD=0.204p PS=0.8u PD=1.835u
M$2035 VDD|vdd \$244 \$336 VDD|vdd sg13_lv_pmos L=0.13u W=0.42u AS=0.204p
+ AD=0.09345p PS=1.835u PD=0.865u
M$2036 \$336 \$263 \$262 VDD|vdd sg13_lv_pmos L=0.13u W=0.42u AS=0.09345p
+ AD=0.2048p PS=0.865u PD=1.63u
M$2037 \$262 \$320 \$235 VDD|vdd sg13_lv_pmos L=0.13u W=1u AS=0.2048p AD=0.34p
+ PS=1.63u PD=2.68u
M$2038 \$320 CLK|X|clknet_2_0__leaf_clk VDD|vdd VDD|vdd sg13_lv_pmos L=0.13u
+ W=1.12u AS=0.4088p AD=0.41165p PS=2.97u PD=2.12u
M$2039 VDD|vdd \$320 \$263 VDD|vdd sg13_lv_pmos L=0.13u W=1.12u AS=0.41165p
+ AD=0.3864p PS=2.12u PD=2.93u
M$2040 VDD|vdd L_HI|RESET_B|net46 \$265 VDD|vdd sg13_lv_pmos L=0.13u W=0.42u
+ AS=0.3623875p AD=0.0798p PS=2.605u PD=0.8u
M$2041 \$265 D|Y|_017_ VDD|vdd VDD|vdd sg13_lv_pmos L=0.13u W=0.42u AS=0.0798p
+ AD=0.1428p PS=0.8u PD=1.52u
M$2042 \$235 \$266 VDD|vdd VDD|vdd sg13_lv_pmos L=0.13u W=1u AS=0.34p
+ AD=0.3623875p PS=2.68u PD=2.605u
M$2043 VDD|vdd A1|X|net80 \$338 VDD|vdd sg13_lv_pmos L=0.15u W=1.12u AS=0.3808p
+ AD=0.2128p PS=2.92u PD=1.5u
M$2044 \$338 A2|A_N|B|X|_027_ A|Y|_050_ VDD|vdd sg13_lv_pmos L=0.15u W=1.12u
+ AS=0.2128p AD=0.2128p PS=1.5u PD=1.5u
M$2045 A|Y|_050_ A|B|B1|Y|_068_ VDD|vdd VDD|vdd sg13_lv_pmos L=0.15u W=1.12u
+ AS=0.2128p AD=0.3808p PS=1.5u PD=2.92u
M$2046 VDD|vdd A|A2|Y|_034_ \$340 VDD|vdd sg13_lv_pmos L=0.13u W=1.12u
+ AS=0.4032p AD=0.1176p PS=2.96u PD=1.33u
M$2047 \$340 B|X|net85 D|Y|_023_ VDD|vdd sg13_lv_pmos L=0.13u W=1.12u
+ AS=0.1176p AD=0.3808p PS=1.33u PD=2.92u
M$2048 VDD|vdd D|Y|_023_ \$248 VDD|vdd sg13_lv_pmos L=0.13u W=0.42u AS=0.1428p
+ AD=0.0798p PS=1.52u PD=0.8u
M$2049 VDD|vdd L_HI|RESET_B|net36 \$248 VDD|vdd sg13_lv_pmos L=0.13u W=0.42u
+ AS=0.3623875p AD=0.0798p PS=2.605u PD=0.8u
M$2050 VDD|vdd \$323 \$236 VDD|vdd sg13_lv_pmos L=0.13u W=1u AS=0.3623875p
+ AD=0.34p PS=2.605u PD=2.68u
M$2051 \$269 \$237 VDD|vdd VDD|vdd sg13_lv_pmos L=0.13u W=1.12u AS=0.3864p
+ AD=0.41165p PS=2.93u PD=2.12u
M$2052 VDD|vdd CLK|X|clknet_2_0__leaf_clk \$237 VDD|vdd sg13_lv_pmos L=0.13u
+ W=1.12u AS=0.41165p AD=0.4088p PS=2.12u PD=2.97u
M$2053 \$270 \$269 \$342 VDD|vdd sg13_lv_pmos L=0.13u W=0.42u AS=0.2048p
+ AD=0.09345p PS=1.63u PD=0.865u
M$2054 \$342 \$250 VDD|vdd VDD|vdd sg13_lv_pmos L=0.13u W=0.42u AS=0.09345p
+ AD=0.204p PS=0.865u PD=1.835u
M$2055 VDD|vdd L_HI|RESET_B|net36 \$250 VDD|vdd sg13_lv_pmos L=0.13u W=0.42u
+ AS=0.204p AD=0.0798p PS=1.835u PD=0.8u
M$2056 \$250 \$270 VDD|vdd VDD|vdd sg13_lv_pmos L=0.13u W=0.42u AS=0.0798p
+ AD=0.4659p PS=0.8u PD=3.65u
M$2057 \$236 \$237 \$270 VDD|vdd sg13_lv_pmos L=0.13u W=1u AS=0.34p AD=0.2048p
+ PS=2.68u PD=1.63u
M$2058 \$251 \$270 VDD|vdd VDD|vdd sg13_lv_pmos L=0.13u W=1.12u AS=0.3864p
+ AD=0.2128p PS=2.93u PD=1.5u
M$2059 VDD|vdd \$251 A|A1|A_N|B|C|Q|counter\[1\] VDD|vdd sg13_lv_pmos L=0.13u
+ W=1.12u AS=0.2128p AD=0.3808p PS=1.5u PD=2.92u
M$2060 VDD|vdd D|X|net87 \$172 VDD|vdd sg13_lv_pmos L=0.13u W=0.42u AS=0.1428p
+ AD=0.0798p PS=1.52u PD=0.8u
M$2061 VDD|vdd L_HI|RESET_B|net44 \$172 VDD|vdd sg13_lv_pmos L=0.13u W=0.42u
+ AS=0.3623875p AD=0.0798p PS=2.605u PD=0.8u
M$2062 VDD|vdd \$174 \$173 VDD|vdd sg13_lv_pmos L=0.13u W=1u AS=0.3623875p
+ AD=0.34p PS=2.605u PD=2.68u
M$2063 VDD|vdd \$272 \$271 VDD|vdd sg13_lv_pmos L=0.5u W=1u AS=0.2254p AD=0.34p
+ PS=1.53u PD=2.68u
M$2064 D|X|net87 \$271 VDD|vdd VDD|vdd sg13_lv_pmos L=0.13u W=1.12u AS=0.4256p
+ AD=0.2254p PS=3u PD=1.53u
M$2065 VDD|vdd L_HI|RESET_B|net44 \$174 VDD|vdd sg13_lv_pmos L=0.13u W=0.42u
+ AS=0.1563p AD=0.147p PS=1.22u PD=1.54u
M$2066 VDD|vdd \$173 \$196 VDD|vdd sg13_lv_pmos L=0.13u W=0.42u AS=0.1563p
+ AD=0.063p PS=1.22u PD=0.72u
M$2067 \$196 \$176 \$174 VDD|vdd sg13_lv_pmos L=0.13u W=0.42u AS=0.063p
+ AD=0.0798p PS=0.72u PD=0.8u
M$2068 \$174 \$175 \$172 VDD|vdd sg13_lv_pmos L=0.13u W=0.42u AS=0.0798p
+ AD=0.1428p PS=0.8u PD=1.52u
M$2069 VDD|vdd A|B|B1|Y|_068_ B1|Y|_058_ VDD|vdd sg13_lv_pmos L=0.15u W=1.12u
+ AS=0.3808p AD=0.2128p PS=2.92u PD=1.5u
M$2070 B1|Y|_058_ A2|B|Y|_090_ \$346 VDD|vdd sg13_lv_pmos L=0.15u W=1.12u
+ AS=0.2128p AD=0.2128p PS=1.5u PD=1.5u
M$2071 \$346 A1|B|B1|C|X|net28 VDD|vdd VDD|vdd sg13_lv_pmos L=0.15u W=1.12u
+ AS=0.2128p AD=0.3808p PS=1.5u PD=2.92u
M$2072 \$173 \$176 \$177 VDD|vdd sg13_lv_pmos L=0.13u W=1u AS=0.34p AD=0.2048p
+ PS=2.68u PD=1.63u
M$2073 \$177 \$175 \$197 VDD|vdd sg13_lv_pmos L=0.13u W=0.42u AS=0.2048p
+ AD=0.09345p PS=1.63u PD=0.865u
M$2074 VDD|vdd \$178 \$197 VDD|vdd sg13_lv_pmos L=0.13u W=0.42u AS=0.204p
+ AD=0.09345p PS=1.835u PD=0.865u
M$2075 VDD|vdd L_HI|RESET_B|net44 \$178 VDD|vdd sg13_lv_pmos L=0.13u W=0.42u
+ AS=0.204p AD=0.0798p PS=1.835u PD=0.8u
M$2076 VDD|vdd \$177 \$178 VDD|vdd sg13_lv_pmos L=0.13u W=0.42u AS=0.4659p
+ AD=0.0798p PS=3.65u PD=0.8u
M$2077 VDD|vdd \$277 \$276 VDD|vdd sg13_lv_pmos L=0.5u W=1u AS=0.2254p AD=0.34p
+ PS=1.53u PD=2.68u
M$2078 A|X|net86 \$276 VDD|vdd VDD|vdd sg13_lv_pmos L=0.13u W=1.12u AS=0.4256p
+ AD=0.2254p PS=3u PD=1.53u
M$2079 VDD|vdd \$281 \$280 VDD|vdd sg13_lv_pmos L=0.13u W=0.66u AS=0.4657125p
+ AD=0.2442p PS=2.54u PD=2.06u
M$2080 L_HI|RESET_B|net44 \$279 VDD|vdd VDD|vdd sg13_lv_pmos L=0.13u W=1.155u
+ AS=0.3927p AD=0.4657125p PS=2.99u PD=2.54u
M$2081 B|B_N|C|X|_077_ \$282 VDD|vdd VDD|vdd sg13_lv_pmos L=0.13u W=1.12u
+ AS=0.3808p AD=0.1918p PS=2.92u PD=1.5u
M$2082 VDD|vdd A2|B|C|Y|_070_ \$282 VDD|vdd sg13_lv_pmos L=0.13u W=0.84u
+ AS=0.1918p AD=0.1596p PS=1.5u PD=1.22u
M$2083 \$282 A|A1|A_N|B|C|Q|counter\[1\] VDD|vdd VDD|vdd sg13_lv_pmos L=0.13u
+ W=0.84u AS=0.1596p AD=0.2856p PS=1.22u PD=2.36u
M$2084 \$283 A|A1|A_N|B|C|Q|counter\[1\] VDD|vdd VDD|vdd sg13_lv_pmos L=0.13u
+ W=0.84u AS=0.2856p AD=0.2198p PS=2.36u PD=1.53u
M$2085 VDD|vdd A|A1|B1|C|Q|counter\[3\] B|B2|C|Y|_079_ VDD|vdd sg13_lv_pmos
+ L=0.13u W=1.12u AS=0.2198p AD=0.2128p PS=1.53u PD=1.5u
M$2086 B|B2|C|Y|_079_ A1|B|B1|C|X|net28 VDD|vdd VDD|vdd sg13_lv_pmos L=0.13u
+ W=1.12u AS=0.2128p AD=0.2128p PS=1.5u PD=1.5u
M$2087 VDD|vdd \$283 B|B2|C|Y|_079_ VDD|vdd sg13_lv_pmos L=0.13u W=1.12u
+ AS=0.2128p AD=0.3808p PS=1.5u PD=2.92u
M$2088 A|A1|X|_071_ \$284 VDD|vdd VDD|vdd sg13_lv_pmos L=0.13u W=1.12u
+ AS=0.3808p AD=0.3808p PS=2.92u PD=2.92u
M$2089 VDD|vdd B1|D|Y|_069_ A|B|Y|_073_ VDD|vdd sg13_lv_pmos L=0.13u W=1.12u
+ AS=0.3808p AD=0.2128p PS=2.92u PD=1.5u
M$2090 A|B|Y|_073_ A1|B|B1|C|X|net28 VDD|vdd VDD|vdd sg13_lv_pmos L=0.13u
+ W=1.12u AS=0.2128p AD=0.2128p PS=1.5u PD=1.5u
M$2091 VDD|vdd A|A1|A_N|B|C|Q|counter\[1\] A|B|Y|_073_ VDD|vdd sg13_lv_pmos
+ L=0.13u W=1.12u AS=0.2128p AD=0.2128p PS=1.5u PD=1.5u
M$2092 A|B|Y|_073_ A|B|B2|Q|counter\[2\] VDD|vdd VDD|vdd sg13_lv_pmos L=0.13u
+ W=1.12u AS=0.2128p AD=0.3808p PS=1.5u PD=2.92u
M$2093 VDD|vdd A_N|B1|Y|_072_ \$286 VDD|vdd sg13_lv_pmos L=0.13u W=0.84u
+ AS=0.2198p AD=0.2856p PS=1.53u PD=2.36u
M$2094 VDD|vdd \$286 A2|B|Y|_032_ VDD|vdd sg13_lv_pmos L=0.13u W=1.12u
+ AS=0.3808p AD=0.2128p PS=2.92u PD=1.5u
M$2095 A2|B|Y|_032_ A|B|C|X|_091_ VDD|vdd VDD|vdd sg13_lv_pmos L=0.13u W=1.12u
+ AS=0.2128p AD=0.2198p PS=1.5u PD=1.53u
M$2096 A|Y|_083_ A_N|B1|Y|_072_ \$329 VDD|vdd sg13_lv_pmos L=0.13u W=1.12u
+ AS=0.3808p AD=0.2128p PS=2.92u PD=1.5u
M$2097 \$329 A|A1|B1|C|Q|counter\[3\] VDD|vdd VDD|vdd sg13_lv_pmos L=0.13u
+ W=1.12u AS=0.2128p AD=0.2128p PS=1.5u PD=1.5u
M$2098 VDD|vdd A1|A2|Y|_060_ \$329 VDD|vdd sg13_lv_pmos L=0.13u W=1.12u
+ AS=0.2128p AD=0.3808p PS=1.5u PD=2.92u
M$2099 A1|A2|Y|_060_ A|X|net78 VDD|vdd VDD|vdd sg13_lv_pmos L=0.13u W=1.12u
+ AS=0.3808p AD=0.3808p PS=2.92u PD=2.92u
M$2100 \$330 A2|B|Y|_032_ VDD|vdd VDD|vdd sg13_lv_pmos L=0.13u W=1.12u
+ AS=0.3808p AD=0.2128p PS=2.92u PD=1.5u
M$2101 VDD|vdd A1|A2|Y|_060_ \$330 VDD|vdd sg13_lv_pmos L=0.13u W=1.12u
+ AS=0.2128p AD=0.2128p PS=1.5u PD=1.5u
M$2102 \$330 A|B1|X|net30 A|Y|_024_ VDD|vdd sg13_lv_pmos L=0.13u W=1.12u
+ AS=0.2128p AD=0.3808p PS=1.5u PD=2.92u
M$2103 VDD|vdd D|X|net79 \$253 VDD|vdd sg13_lv_pmos L=0.13u W=0.42u AS=0.1428p
+ AD=0.0798p PS=1.52u PD=0.8u
M$2104 VDD|vdd L_HI|RESET_B|net48 \$253 VDD|vdd sg13_lv_pmos L=0.13u W=0.42u
+ AS=0.3623875p AD=0.0798p PS=2.605u PD=0.8u
M$2105 VDD|vdd \$331 \$238 VDD|vdd sg13_lv_pmos L=0.13u W=1u AS=0.3623875p
+ AD=0.34p PS=2.605u PD=2.68u
M$2106 \$289 \$239 VDD|vdd VDD|vdd sg13_lv_pmos L=0.13u W=1.12u AS=0.3864p
+ AD=0.41165p PS=2.93u PD=2.12u
M$2107 VDD|vdd CLK|X|clknet_2_2__leaf_clk \$239 VDD|vdd sg13_lv_pmos L=0.13u
+ W=1.12u AS=0.41165p AD=0.4088p PS=2.12u PD=2.97u
M$2108 \$290 \$289 \$351 VDD|vdd sg13_lv_pmos L=0.13u W=0.42u AS=0.2048p
+ AD=0.09345p PS=1.63u PD=0.865u
M$2109 \$351 \$255 VDD|vdd VDD|vdd sg13_lv_pmos L=0.13u W=0.42u AS=0.09345p
+ AD=0.204p PS=0.865u PD=1.835u
M$2110 VDD|vdd L_HI|RESET_B|net48 \$255 VDD|vdd sg13_lv_pmos L=0.13u W=0.42u
+ AS=0.204p AD=0.0798p PS=1.835u PD=0.8u
M$2111 \$255 \$290 VDD|vdd VDD|vdd sg13_lv_pmos L=0.13u W=0.42u AS=0.0798p
+ AD=0.4659p PS=0.8u PD=3.65u
M$2112 \$238 \$239 \$290 VDD|vdd sg13_lv_pmos L=0.13u W=1u AS=0.34p AD=0.2048p
+ PS=2.68u PD=1.63u
M$2113 \$256 \$290 VDD|vdd VDD|vdd sg13_lv_pmos L=0.13u W=1.12u AS=0.3864p
+ AD=0.2128p PS=2.93u PD=1.5u
M$2114 VDD|vdd \$256 A|B|B2|Q|counter\[2\] VDD|vdd sg13_lv_pmos L=0.13u W=1.12u
+ AS=0.2128p AD=0.3808p PS=1.5u PD=2.92u
M$2115 VDD|vdd D|Y|_002_ \$257 VDD|vdd sg13_lv_pmos L=0.13u W=0.42u AS=0.1428p
+ AD=0.0798p PS=1.52u PD=0.8u
M$2116 VDD|vdd L_HI|RESET_B|net57 \$257 VDD|vdd sg13_lv_pmos L=0.13u W=0.42u
+ AS=0.3623875p AD=0.0798p PS=2.605u PD=0.8u
M$2117 VDD|vdd \$332 \$240 VDD|vdd sg13_lv_pmos L=0.13u W=1u AS=0.3623875p
+ AD=0.34p PS=2.605u PD=2.68u
M$2118 \$292 \$241 VDD|vdd VDD|vdd sg13_lv_pmos L=0.13u W=1.12u AS=0.3864p
+ AD=0.41165p PS=2.93u PD=2.12u
M$2119 VDD|vdd CLK|X|clknet_2_2__leaf_clk \$241 VDD|vdd sg13_lv_pmos L=0.13u
+ W=1.12u AS=0.41165p AD=0.4088p PS=2.12u PD=2.97u
M$2120 \$293 \$292 \$345 VDD|vdd sg13_lv_pmos L=0.13u W=0.42u AS=0.2048p
+ AD=0.09345p PS=1.63u PD=0.865u
M$2121 \$345 \$259 VDD|vdd VDD|vdd sg13_lv_pmos L=0.13u W=0.42u AS=0.09345p
+ AD=0.204p PS=0.865u PD=1.835u
M$2122 VDD|vdd L_HI|RESET_B|net57 \$259 VDD|vdd sg13_lv_pmos L=0.13u W=0.42u
+ AS=0.204p AD=0.0798p PS=1.835u PD=0.8u
M$2123 \$259 \$293 VDD|vdd VDD|vdd sg13_lv_pmos L=0.13u W=0.42u AS=0.0798p
+ AD=0.4659p PS=0.8u PD=3.65u
M$2124 \$240 \$241 \$293 VDD|vdd sg13_lv_pmos L=0.13u W=1u AS=0.34p AD=0.2048p
+ PS=2.68u PD=1.63u
M$2125 \$260 \$293 VDD|vdd VDD|vdd sg13_lv_pmos L=0.13u W=1.12u AS=0.3864p
+ AD=0.2128p PS=2.93u PD=1.5u
M$2126 VDD|vdd \$260 A|Q|net14 VDD|vdd sg13_lv_pmos L=0.13u W=1.12u AS=0.2128p
+ AD=0.3808p PS=1.5u PD=2.92u
M$2127 VDD|vdd A|Q|net14 \$295 VDD|vdd sg13_lv_pmos L=0.13u W=0.84u AS=0.2114p
+ AD=0.2856p PS=1.54u PD=2.36u
M$2128 VDD|vdd \$295 B[2]|X VDD|vdd sg13_lv_pmos L=0.13u W=1.12u AS=0.2114p
+ AD=0.42p PS=1.54u PD=2.99u
M$2149 \$265 \$263 \$266 VDD|vdd sg13_lv_pmos L=0.13u W=0.42u AS=0.1428p
+ AD=0.0798p PS=1.52u PD=0.8u
M$2150 \$266 \$320 \$337 VDD|vdd sg13_lv_pmos L=0.13u W=0.42u AS=0.0798p
+ AD=0.063p PS=0.8u PD=0.72u
M$2151 \$337 \$235 VDD|vdd VDD|vdd sg13_lv_pmos L=0.13u W=0.42u AS=0.063p
+ AD=0.1563p PS=0.72u PD=1.22u
M$2152 VDD|vdd L_HI|RESET_B|net46 \$266 VDD|vdd sg13_lv_pmos L=0.13u W=0.42u
+ AS=0.1563p AD=0.147p PS=1.22u PD=1.54u
M$2154 VDD|vdd A1|Y|_061_ \$396 VDD|vdd sg13_lv_pmos L=0.15u W=1.12u AS=0.3808p
+ AD=0.2128p PS=2.92u PD=1.5u
M$2155 \$396 A|A2|Y|_034_ D|Y|_018_ VDD|vdd sg13_lv_pmos L=0.15u W=1.12u
+ AS=0.2128p AD=0.2128p PS=1.5u PD=1.5u
M$2156 D|Y|_018_ B1|Y|_051_ VDD|vdd VDD|vdd sg13_lv_pmos L=0.15u W=1.12u
+ AS=0.2128p AD=0.3808p PS=1.5u PD=2.92u
M$2157 \$323 L_HI|RESET_B|net36 VDD|vdd VDD|vdd sg13_lv_pmos L=0.13u W=0.42u
+ AS=0.147p AD=0.1563p PS=1.54u PD=1.22u
M$2158 VDD|vdd \$236 \$341 VDD|vdd sg13_lv_pmos L=0.13u W=0.42u AS=0.1563p
+ AD=0.063p PS=1.22u PD=0.72u
M$2159 \$341 \$237 \$323 VDD|vdd sg13_lv_pmos L=0.13u W=0.42u AS=0.063p
+ AD=0.0798p PS=0.72u PD=0.8u
M$2160 \$323 \$269 \$248 VDD|vdd sg13_lv_pmos L=0.13u W=0.42u AS=0.0798p
+ AD=0.1428p PS=0.8u PD=1.52u
M$2161 VDD|vdd \$387 L_HI|RESET_B|net36 VDD|vdd sg13_lv_pmos L=0.13u W=1.155u
+ AS=0.4657125p AD=0.3927p PS=2.54u PD=2.99u
M$2162 VDD|vdd \$389 \$388 VDD|vdd sg13_lv_pmos L=0.13u W=0.66u AS=0.4657125p
+ AD=0.2442p PS=2.54u PD=2.06u
M$2167 VDD|vdd A|Y|_022_ \$273 VDD|vdd sg13_lv_pmos L=0.13u W=0.42u AS=0.1523p
+ AD=0.1428p PS=1.38u PD=1.52u
M$2168 \$272 \$273 VDD|vdd VDD|vdd sg13_lv_pmos L=0.5u W=1u AS=0.34p AD=0.1523p
+ PS=2.68u PD=1.38u
M$2169 VDD|vdd A|A2|X|net2 B1|Y|_051_ VDD|vdd sg13_lv_pmos L=0.13u W=1.12u
+ AS=0.3808p AD=0.2128p PS=2.92u PD=1.5u
M$2170 B1|Y|_051_ A|B|B1|Y|_068_ VDD|vdd VDD|vdd sg13_lv_pmos L=0.13u W=1.12u
+ AS=0.2128p AD=0.2128p PS=1.5u PD=1.5u
M$2171 VDD|vdd A2|B|C|D|X|net27 B1|Y|_051_ VDD|vdd sg13_lv_pmos L=0.13u W=1.12u
+ AS=0.2128p AD=0.2128p PS=1.5u PD=1.5u
M$2172 B1|Y|_051_ C|D|Y|_030_ VDD|vdd VDD|vdd sg13_lv_pmos L=0.13u W=1.12u
+ AS=0.2128p AD=0.3808p PS=1.5u PD=2.92u
M$2173 VDD|vdd A|B|Y|_073_ \$274 VDD|vdd sg13_lv_pmos L=0.13u W=0.84u
+ AS=0.2856p AD=0.1596p PS=2.36u PD=1.22u
M$2174 VDD|vdd A2|B|Y|_090_ \$274 VDD|vdd sg13_lv_pmos L=0.13u W=0.84u
+ AS=0.1918p AD=0.1596p PS=1.5u PD=1.22u
M$2175 VDD|vdd \$274 A|B|C|X|_091_ VDD|vdd sg13_lv_pmos L=0.13u W=1.12u
+ AS=0.1918p AD=0.3808p PS=1.5u PD=2.92u
M$2176 VDD|vdd B|C|D|Y|_097_ B|Y|_100_ VDD|vdd sg13_lv_pmos L=0.13u W=1.12u
+ AS=0.3808p AD=0.2128p PS=2.92u PD=1.5u
M$2177 B|Y|_100_ A2|B|C|D|X|net27 VDD|vdd VDD|vdd sg13_lv_pmos L=0.13u W=1.12u
+ AS=0.2128p AD=0.2128p PS=1.5u PD=1.5u
M$2178 VDD|vdd A|B|D|X|_085_ B|Y|_100_ VDD|vdd sg13_lv_pmos L=0.13u W=1.12u
+ AS=0.2128p AD=0.3808p PS=1.5u PD=2.92u
M$2179 VDD|vdd A|A2|Q|counter\[0\] \$278 VDD|vdd sg13_lv_pmos L=0.13u W=0.42u
+ AS=0.1523p AD=0.1428p PS=1.38u PD=1.52u
M$2180 \$277 \$278 VDD|vdd VDD|vdd sg13_lv_pmos L=0.5u W=1u AS=0.34p AD=0.1523p
+ PS=2.68u PD=1.38u
M$2183 VDD|vdd B|B_N|C|X|_077_ A|B|B1|Y|_078_ VDD|vdd sg13_lv_pmos L=0.13u
+ W=1.12u AS=0.3808p AD=0.2128p PS=2.92u PD=1.5u
M$2184 A|B|B1|Y|_078_ B|C|Y|_074_ VDD|vdd VDD|vdd sg13_lv_pmos L=0.13u W=1.12u
+ AS=0.2128p AD=0.2128p PS=1.5u PD=1.5u
M$2185 VDD|vdd A|B|Y|_073_ A|B|B1|Y|_078_ VDD|vdd sg13_lv_pmos L=0.13u W=1.12u
+ AS=0.2128p AD=0.3808p PS=1.5u PD=2.92u
M$2186 A|B|Y|_076_ A|A1|X|_071_ VDD|vdd VDD|vdd sg13_lv_pmos L=0.13u W=1.12u
+ AS=0.3808p AD=0.2128p PS=2.92u PD=1.5u
M$2187 VDD|vdd A|B|Y|_073_ A|B|Y|_076_ VDD|vdd sg13_lv_pmos L=0.13u W=1.12u
+ AS=0.2128p AD=0.2128p PS=1.5u PD=1.5u
M$2188 A|B|Y|_076_ B|C|Y|_074_ VDD|vdd VDD|vdd sg13_lv_pmos L=0.13u W=1.12u
+ AS=0.2128p AD=0.3808p PS=1.5u PD=2.92u
M$2189 \$284 A1|B|B1|C|X|net28 \$326 VDD|vdd sg13_lv_pmos L=0.13u W=1u AS=0.35p
+ AD=0.2125p PS=2.7u PD=1.425u
M$2190 \$326 A|A1|B1|C|Q|counter\[3\] VDD|vdd VDD|vdd sg13_lv_pmos L=0.13u W=1u
+ AS=0.2125p AD=0.19p PS=1.425u PD=1.38u
M$2191 VDD|vdd A2|B|C|Y|_070_ \$326 VDD|vdd sg13_lv_pmos L=0.13u W=1u AS=0.19p
+ AD=0.34p PS=1.38u PD=2.68u
M$2192 VDD|vdd A|Y|_083_ \$380 VDD|vdd sg13_lv_pmos L=0.13u W=0.84u AS=0.2226p
+ AD=0.1596p PS=1.535u PD=1.22u
M$2193 \$380 B|Y|_084_ \$392 VDD|vdd sg13_lv_pmos L=0.13u W=0.84u AS=0.1596p
+ AD=0.2856p PS=1.22u PD=2.36u
M$2194 A|B|D|X|_085_ \$392 VDD|vdd VDD|vdd sg13_lv_pmos L=0.13u W=1.12u
+ AS=0.3976p AD=0.2226p PS=2.95u PD=1.535u
M$2201 \$331 L_HI|RESET_B|net48 VDD|vdd VDD|vdd sg13_lv_pmos L=0.13u W=0.42u
+ AS=0.147p AD=0.1563p PS=1.54u PD=1.22u
M$2202 VDD|vdd \$238 \$352 VDD|vdd sg13_lv_pmos L=0.13u W=0.42u AS=0.1563p
+ AD=0.063p PS=1.22u PD=0.72u
M$2203 \$352 \$239 \$331 VDD|vdd sg13_lv_pmos L=0.13u W=0.42u AS=0.063p
+ AD=0.0798p PS=0.72u PD=0.8u
M$2204 \$331 \$289 \$253 VDD|vdd sg13_lv_pmos L=0.13u W=0.42u AS=0.0798p
+ AD=0.1428p PS=0.8u PD=1.52u
M$2205 \$332 L_HI|RESET_B|net57 VDD|vdd VDD|vdd sg13_lv_pmos L=0.13u W=0.42u
+ AS=0.147p AD=0.1563p PS=1.54u PD=1.22u
M$2206 VDD|vdd \$240 \$348 VDD|vdd sg13_lv_pmos L=0.13u W=0.42u AS=0.1563p
+ AD=0.063p PS=1.22u PD=0.72u
M$2207 \$348 \$241 \$332 VDD|vdd sg13_lv_pmos L=0.13u W=0.42u AS=0.063p
+ AD=0.0798p PS=0.72u PD=0.8u
M$2208 \$332 \$292 \$257 VDD|vdd sg13_lv_pmos L=0.13u W=0.42u AS=0.0798p
+ AD=0.1428p PS=0.8u PD=1.52u
M$2245 A|Q|net8 \$359 VDD|vdd VDD|vdd sg13_lv_pmos L=0.13u W=1.12u AS=0.3808p
+ AD=0.2128p PS=2.92u PD=1.5u
M$2246 VDD|vdd \$381 \$359 VDD|vdd sg13_lv_pmos L=0.13u W=1.12u AS=0.2128p
+ AD=0.3864p PS=1.5u PD=2.93u
M$2247 VDD|vdd CLK|X|clknet_2_0__leaf_clk \$383 VDD|vdd sg13_lv_pmos L=0.13u
+ W=1.12u AS=0.41165p AD=0.4088p PS=2.12u PD=2.97u
M$2248 VDD|vdd \$383 \$361 VDD|vdd sg13_lv_pmos L=0.13u W=1.12u AS=0.41165p
+ AD=0.3864p PS=2.12u PD=2.93u
M$2249 \$362 \$361 \$363 VDD|vdd sg13_lv_pmos L=0.13u W=0.42u AS=0.1428p
+ AD=0.0798p PS=1.52u PD=0.8u
M$2250 \$363 \$383 \$379 VDD|vdd sg13_lv_pmos L=0.13u W=0.42u AS=0.0798p
+ AD=0.063p PS=0.8u PD=0.72u
M$2251 VDD|vdd \$382 \$379 VDD|vdd sg13_lv_pmos L=0.13u W=0.42u AS=0.1563p
+ AD=0.063p PS=1.22u PD=0.72u
M$2252 VDD|vdd L_HI|RESET_B|net42 \$363 VDD|vdd sg13_lv_pmos L=0.13u W=0.42u
+ AS=0.1563p AD=0.147p PS=1.22u PD=1.54u
M$2253 VDD|vdd \$363 \$382 VDD|vdd sg13_lv_pmos L=0.13u W=1u AS=0.3623875p
+ AD=0.34p PS=2.605u PD=2.68u
M$2254 VDD|vdd L_HI|RESET_B|net42 \$362 VDD|vdd sg13_lv_pmos L=0.13u W=0.42u
+ AS=0.3623875p AD=0.0798p PS=2.605u PD=0.8u
M$2255 \$362 D|Y|_018_ VDD|vdd VDD|vdd sg13_lv_pmos L=0.13u W=0.42u AS=0.0798p
+ AD=0.1428p PS=0.8u PD=1.52u
M$2256 VDD|vdd A2|A_N|B|X|_027_ A1|A2|B_N|Y|_028_ VDD|vdd sg13_lv_pmos L=0.13u
+ W=1.12u AS=0.3808p AD=0.2128p PS=2.92u PD=1.5u
M$2257 A1|A2|B_N|Y|_028_ A|A1|X|net33 VDD|vdd VDD|vdd sg13_lv_pmos L=0.13u
+ W=1.12u AS=0.2128p AD=0.3808p PS=1.5u PD=2.92u
M$2258 \$364 A|A1|X|net3 VDD|vdd VDD|vdd sg13_lv_pmos L=0.13u W=0.84u
+ AS=0.2856p AD=0.2114p PS=2.36u PD=1.54u
M$2259 VDD|vdd \$364 A|A1|X|net33 VDD|vdd sg13_lv_pmos L=0.13u W=1.12u
+ AS=0.2114p AD=0.42p PS=1.54u PD=2.99u
M$2261 B1|X|net84 \$365 VDD|vdd VDD|vdd sg13_lv_pmos L=0.13u W=1.12u AS=0.4256p
+ AD=0.2254p PS=3u PD=1.53u
M$2262 VDD|vdd \$366 \$365 VDD|vdd sg13_lv_pmos L=0.5u W=1u AS=0.2254p AD=0.34p
+ PS=1.53u PD=2.68u
M$2263 VDD|vdd A|A1|A_N|B|C|Q|counter\[1\] \$367 VDD|vdd sg13_lv_pmos L=0.13u
+ W=0.42u AS=0.1523p AD=0.1428p PS=1.38u PD=1.52u
M$2264 \$366 \$367 VDD|vdd VDD|vdd sg13_lv_pmos L=0.5u W=1u AS=0.34p AD=0.1523p
+ PS=2.68u PD=1.38u
M$2265 VDD|vdd A|B|Y|_076_ \$397 VDD|vdd sg13_lv_pmos L=0.13u W=1.12u
+ AS=0.4032p AD=0.1176p PS=2.96u PD=1.33u
M$2266 \$397 B|B_N|C|X|_077_ B|C|D|Y|_097_ VDD|vdd sg13_lv_pmos L=0.13u W=1.12u
+ AS=0.1176p AD=0.3808p PS=1.33u PD=2.92u
M$2267 VDD|vdd A|B|Y|_073_ A2|B|C|Y|_092_ VDD|vdd sg13_lv_pmos L=0.13u W=1.12u
+ AS=0.3808p AD=0.2128p PS=2.92u PD=1.5u
M$2268 A2|B|C|Y|_092_ A2|B|Y|_090_ VDD|vdd VDD|vdd sg13_lv_pmos L=0.13u W=1.12u
+ AS=0.2128p AD=0.3808p PS=1.5u PD=2.92u
M$2269 VDD|vdd A|B|C|X|_091_ \$370 VDD|vdd sg13_lv_pmos L=0.13u W=0.84u
+ AS=0.2114p AD=0.2856p PS=1.54u PD=2.36u
M$2270 A2|B|C|D|X|net27 \$370 VDD|vdd VDD|vdd sg13_lv_pmos L=0.13u W=1.12u
+ AS=0.42p AD=0.2114p PS=2.99u PD=1.54u
M$2271 VDD|vdd B|C|Y|_074_ \$372 VDD|vdd sg13_lv_pmos L=0.13u W=0.84u
+ AS=0.1918p AD=0.1596p PS=1.5u PD=1.22u
M$2272 \$372 A|B|Y|_073_ VDD|vdd VDD|vdd sg13_lv_pmos L=0.13u W=0.84u
+ AS=0.1596p AD=0.2856p PS=1.22u PD=2.36u
M$2273 A2|X|_075_ \$372 VDD|vdd VDD|vdd sg13_lv_pmos L=0.13u W=1.12u AS=0.3808p
+ AD=0.1918p PS=2.92u PD=1.5u
M$2274 VDD|vdd A1|B|B1|C|X|net28 A_N|B1|Y|_072_ VDD|vdd sg13_lv_pmos L=0.13u
+ W=1.12u AS=0.3808p AD=0.2128p PS=2.92u PD=1.5u
M$2275 A_N|B1|Y|_072_ A|A1|A_N|B|C|Q|counter\[1\] VDD|vdd VDD|vdd sg13_lv_pmos
+ L=0.13u W=1.12u AS=0.2128p AD=0.3808p PS=1.5u PD=2.92u
M$2276 VDD|vdd A2|B|Y|_032_ A2|Y|_033_ VDD|vdd sg13_lv_pmos L=0.13u W=1.12u
+ AS=0.3808p AD=0.2128p PS=2.92u PD=1.5u
M$2277 A2|Y|_033_ A|X|net70 VDD|vdd VDD|vdd sg13_lv_pmos L=0.13u W=1.12u
+ AS=0.2128p AD=0.3808p PS=1.5u PD=2.92u
M$2278 VDD|vdd A2|A_N|B|X|_027_ \$373 VDD|vdd sg13_lv_pmos L=0.13u W=0.84u
+ AS=0.2198p AD=0.2856p PS=1.53u PD=2.36u
M$2279 VDD|vdd B|X|net76 A2|Y|_029_ VDD|vdd sg13_lv_pmos L=0.13u W=1.12u
+ AS=0.2198p AD=0.2128p PS=1.53u PD=1.5u
M$2280 A2|Y|_029_ \$373 VDD|vdd VDD|vdd sg13_lv_pmos L=0.13u W=1.12u AS=0.2128p
+ AD=0.3808p PS=1.5u PD=2.92u
M$2281 VDD|vdd A|X|clknet_0_clk \$375 VDD|vdd sg13_lv_pmos L=0.13u W=6.72u
+ AS=1.4448p AD=1.2768p PS=10.42u PD=9u
M$2287 VDD|vdd \$375 CLK|X|clknet_2_2__leaf_clk VDD|vdd sg13_lv_pmos L=0.13u
+ W=17.92u AS=3.4048p AD=3.5896p PS=24u PD=25.45u
M$2303 B|X|net76 \$376 VDD|vdd VDD|vdd sg13_lv_pmos L=0.13u W=1.12u AS=0.4256p
+ AD=0.2254p PS=3u PD=1.53u
M$2304 VDD|vdd \$377 \$376 VDD|vdd sg13_lv_pmos L=0.5u W=1u AS=0.2254p AD=0.34p
+ PS=1.53u PD=2.68u
M$2305 VDD|vdd A|Q|net14 \$378 VDD|vdd sg13_lv_pmos L=0.13u W=0.42u AS=0.1523p
+ AD=0.1428p PS=1.38u PD=1.52u
M$2306 \$377 \$378 VDD|vdd VDD|vdd sg13_lv_pmos L=0.5u W=1u AS=0.34p AD=0.1523p
+ PS=2.68u PD=1.38u
M$2320 VDD|vdd \$381 \$360 VDD|vdd sg13_lv_pmos L=0.13u W=0.42u AS=0.4659p
+ AD=0.0798p PS=3.65u PD=0.8u
M$2321 VDD|vdd L_HI|RESET_B|net42 \$360 VDD|vdd sg13_lv_pmos L=0.13u W=0.42u
+ AS=0.204p AD=0.0798p PS=1.835u PD=0.8u
M$2322 VDD|vdd \$360 \$395 VDD|vdd sg13_lv_pmos L=0.13u W=0.42u AS=0.204p
+ AD=0.09345p PS=1.835u PD=0.865u
M$2323 \$381 \$361 \$395 VDD|vdd sg13_lv_pmos L=0.13u W=0.42u AS=0.2048p
+ AD=0.09345p PS=1.63u PD=0.865u
M$2324 \$381 \$383 \$382 VDD|vdd sg13_lv_pmos L=0.13u W=1u AS=0.2048p AD=0.34p
+ PS=1.63u PD=2.68u
M$2325 \$446 \$445 VDD|vdd VDD|vdd sg13_lv_pmos L=0.13u W=0.66u AS=0.2442p
+ AD=0.4657125p PS=2.06u PD=2.54u
M$2326 VDD|vdd \$447 L_HI|RESET_B|net42 VDD|vdd sg13_lv_pmos L=0.13u W=1.155u
+ AS=0.4657125p AD=0.3927p PS=2.54u PD=2.99u
M$2327 \$448 A1|A2|B_N|Y|_094_ VDD|vdd VDD|vdd sg13_lv_pmos L=0.13u W=0.84u
+ AS=0.2856p AD=0.2618p PS=2.36u PD=1.63u
M$2328 VDD|vdd \$448 \$492 VDD|vdd sg13_lv_pmos L=0.13u W=1.12u AS=0.2618p
+ AD=0.1176p PS=1.63u PD=1.33u
M$2329 \$492 A|Y|_046_ D|Y|_015_ VDD|vdd sg13_lv_pmos L=0.13u W=1.12u
+ AS=0.1176p AD=0.3808p PS=1.33u PD=2.92u
M$2330 VDD|vdd A|Q|net8 \$429 VDD|vdd sg13_lv_pmos L=0.13u W=0.42u AS=0.1523p
+ AD=0.1428p PS=1.38u PD=1.52u
M$2331 VDD|vdd \$429 \$430 VDD|vdd sg13_lv_pmos L=0.5u W=1u AS=0.1523p AD=0.34p
+ PS=1.38u PD=2.68u
M$2332 \$450 \$430 VDD|vdd VDD|vdd sg13_lv_pmos L=0.5u W=1u AS=0.34p AD=0.2254p
+ PS=2.68u PD=1.53u
M$2333 VDD|vdd \$450 A|X|net69 VDD|vdd sg13_lv_pmos L=0.13u W=1.12u AS=0.2254p
+ AD=0.4256p PS=1.53u PD=3u
M$2334 VDD|vdd A|B1|X|net29 A|B|B1|Y|_068_ VDD|vdd sg13_lv_pmos L=0.13u W=1.12u
+ AS=0.3808p AD=0.3808p PS=2.92u PD=2.92u
M$2335 VDD|vdd A|X|net69 A1|Y|_061_ VDD|vdd sg13_lv_pmos L=0.13u W=1.12u
+ AS=0.3808p AD=0.3808p PS=2.92u PD=2.92u
M$2339 VDD|vdd \$453 \$452 VDD|vdd sg13_lv_pmos L=0.13u W=0.66u AS=0.4657125p
+ AD=0.2442p PS=2.54u PD=2.06u
M$2340 L_HI|RESET_B|net40 \$451 VDD|vdd VDD|vdd sg13_lv_pmos L=0.13u W=1.155u
+ AS=0.3927p AD=0.4657125p PS=2.99u PD=2.54u
M$2342 VDD|vdd \$433 CLK|X|clknet_2_0__leaf_clk VDD|vdd sg13_lv_pmos L=0.13u
+ W=17.92u AS=3.5896p AD=3.4048p PS=25.45u PD=24u
M$2358 VDD|vdd A|X|clknet_0_clk \$433 VDD|vdd sg13_lv_pmos L=0.13u W=6.72u
+ AS=1.2768p AD=1.4448p PS=9u PD=10.42u
M$2364 VDD|vdd C|D|Y|_030_ A1|A2|Y|_031_ VDD|vdd sg13_lv_pmos L=0.13u W=1.12u
+ AS=0.3808p AD=0.2128p PS=2.92u PD=1.5u
M$2365 A1|A2|Y|_031_ A2|B|C|D|X|net27 VDD|vdd VDD|vdd sg13_lv_pmos L=0.13u
+ W=1.12u AS=0.2128p AD=0.2128p PS=1.5u PD=1.5u
M$2366 VDD|vdd A|A1|X|net33 A1|A2|Y|_031_ VDD|vdd sg13_lv_pmos L=0.13u W=1.12u
+ AS=0.2128p AD=0.3808p PS=1.5u PD=2.92u
M$2367 VDD|vdd B|B_N|C|X|_077_ \$454 VDD|vdd sg13_lv_pmos L=0.13u W=0.84u
+ AS=0.2618p AD=0.2856p PS=1.63u PD=2.36u
M$2368 C|D|Y|_030_ A|B|Y|_076_ \$498 VDD|vdd sg13_lv_pmos L=0.13u W=1.12u
+ AS=0.3808p AD=0.1176p PS=2.92u PD=1.33u
M$2369 \$498 \$454 VDD|vdd VDD|vdd sg13_lv_pmos L=0.13u W=1.12u AS=0.1176p
+ AD=0.2618p PS=1.33u PD=1.63u
M$2375 VDD|vdd A|A1|X|_071_ \$487 VDD|vdd sg13_lv_pmos L=0.13u W=1.12u
+ AS=0.3808p AD=0.2716p PS=2.92u PD=1.605u
M$2376 \$487 A|B|B1|Y|_078_ C|D|Y|_026_ VDD|vdd sg13_lv_pmos L=0.13u W=1.12u
+ AS=0.2716p AD=0.2128p PS=1.605u PD=1.5u
M$2377 C|D|Y|_026_ B|B2|C|Y|_079_ \$487 VDD|vdd sg13_lv_pmos L=0.13u W=1.12u
+ AS=0.2128p AD=0.2744p PS=1.5u PD=1.61u
M$2378 \$487 A2|X|_075_ VDD|vdd VDD|vdd sg13_lv_pmos L=0.13u W=1.12u AS=0.2744p
+ AD=0.3808p PS=1.61u PD=2.92u
M$2379 VDD|vdd A|B|Y|_076_ A|A1|Y|_087_ VDD|vdd sg13_lv_pmos L=0.13u W=1.12u
+ AS=0.3808p AD=0.2128p PS=2.92u PD=1.5u
M$2380 A|A1|Y|_087_ A|B|B1|Y|_078_ VDD|vdd VDD|vdd sg13_lv_pmos L=0.13u W=1.12u
+ AS=0.2128p AD=0.2128p PS=1.5u PD=1.5u
M$2381 VDD|vdd B|B2|C|Y|_079_ A|A1|Y|_087_ VDD|vdd sg13_lv_pmos L=0.13u W=1.12u
+ AS=0.2128p AD=0.2128p PS=1.5u PD=1.5u
M$2382 A|A1|Y|_087_ A|B|D|X|_085_ VDD|vdd VDD|vdd sg13_lv_pmos L=0.13u W=1.12u
+ AS=0.2128p AD=0.3808p PS=1.5u PD=2.92u
M$2383 VDD|vdd C|D|Y|_026_ \$480 VDD|vdd sg13_lv_pmos L=0.13u W=0.84u
+ AS=0.36195p AD=0.1596p PS=1.84u PD=1.22u
M$2384 \$480 A|B|C|X|_091_ VDD|vdd VDD|vdd sg13_lv_pmos L=0.13u W=0.84u
+ AS=0.1596p AD=0.1596p PS=1.22u PD=1.22u
M$2385 VDD|vdd A|B|D|X|_085_ \$480 VDD|vdd sg13_lv_pmos L=0.13u W=0.84u
+ AS=0.1596p AD=0.2856p PS=1.22u PD=2.36u
M$2386 A2|A_N|B|X|_027_ \$480 VDD|vdd VDD|vdd sg13_lv_pmos L=0.13u W=1.12u
+ AS=0.3808p AD=0.36195p PS=2.92u PD=1.84u
M$2387 A|Y|_082_ A|B|Y|_076_ VDD|vdd VDD|vdd sg13_lv_pmos L=0.13u W=1.12u
+ AS=0.3808p AD=0.2128p PS=2.92u PD=1.5u
M$2388 VDD|vdd A|B|B1|Y|_078_ A|Y|_082_ VDD|vdd sg13_lv_pmos L=0.13u W=1.12u
+ AS=0.2128p AD=0.2128p PS=1.5u PD=1.5u
M$2389 A|Y|_082_ B|B2|C|Y|_079_ VDD|vdd VDD|vdd sg13_lv_pmos L=0.13u W=1.12u
+ AS=0.2128p AD=0.3808p PS=1.5u PD=2.92u
M$2394 D|Y|_003_ A|B1|X|net30 \$481 VDD|vdd sg13_lv_pmos L=0.13u W=1.12u
+ AS=0.3808p AD=0.2128p PS=2.92u PD=1.5u
M$2395 \$481 A1|A2|Y|_031_ VDD|vdd VDD|vdd sg13_lv_pmos L=0.13u W=1.12u
+ AS=0.2128p AD=0.2128p PS=1.5u PD=1.5u
M$2396 VDD|vdd A2|Y|_033_ \$481 VDD|vdd sg13_lv_pmos L=0.13u W=1.12u AS=0.2128p
+ AD=0.3808p PS=1.5u PD=2.92u
M$2397 VDD|vdd D|Y|_003_ \$436 VDD|vdd sg13_lv_pmos L=0.13u W=0.42u AS=0.1428p
+ AD=0.0798p PS=1.52u PD=0.8u
M$2398 VDD|vdd L_HI|RESET_B|net55 \$436 VDD|vdd sg13_lv_pmos L=0.13u W=0.42u
+ AS=0.3623875p AD=0.0798p PS=2.605u PD=0.8u
M$2399 VDD|vdd \$482 \$437 VDD|vdd sg13_lv_pmos L=0.13u W=1u AS=0.3623875p
+ AD=0.34p PS=2.605u PD=2.68u
M$2400 \$482 L_HI|RESET_B|net55 VDD|vdd VDD|vdd sg13_lv_pmos L=0.13u W=0.42u
+ AS=0.147p AD=0.1563p PS=1.54u PD=1.22u
M$2401 VDD|vdd \$437 \$500 VDD|vdd sg13_lv_pmos L=0.13u W=0.42u AS=0.1563p
+ AD=0.063p PS=1.22u PD=0.72u
M$2402 \$500 \$438 \$482 VDD|vdd sg13_lv_pmos L=0.13u W=0.42u AS=0.063p
+ AD=0.0798p PS=0.72u PD=0.8u
M$2403 \$482 \$458 \$436 VDD|vdd sg13_lv_pmos L=0.13u W=0.42u AS=0.0798p
+ AD=0.1428p PS=0.8u PD=1.52u
M$2404 \$458 \$438 VDD|vdd VDD|vdd sg13_lv_pmos L=0.13u W=1.12u AS=0.3864p
+ AD=0.41165p PS=2.93u PD=2.12u
M$2405 VDD|vdd CLK|X|clknet_2_2__leaf_clk \$438 VDD|vdd sg13_lv_pmos L=0.13u
+ W=1.12u AS=0.41165p AD=0.4088p PS=2.12u PD=2.97u
M$2406 \$459 \$458 \$499 VDD|vdd sg13_lv_pmos L=0.13u W=0.42u AS=0.2048p
+ AD=0.09345p PS=1.63u PD=0.865u
M$2407 \$499 \$440 VDD|vdd VDD|vdd sg13_lv_pmos L=0.13u W=0.42u AS=0.09345p
+ AD=0.204p PS=0.865u PD=1.835u
M$2408 VDD|vdd L_HI|RESET_B|net55 \$440 VDD|vdd sg13_lv_pmos L=0.13u W=0.42u
+ AS=0.204p AD=0.0798p PS=1.835u PD=0.8u
M$2409 \$440 \$459 VDD|vdd VDD|vdd sg13_lv_pmos L=0.13u W=0.42u AS=0.0798p
+ AD=0.4659p PS=0.8u PD=3.65u
M$2410 \$437 \$438 \$459 VDD|vdd sg13_lv_pmos L=0.13u W=1u AS=0.34p AD=0.2048p
+ PS=2.68u PD=1.63u
M$2411 \$441 \$459 VDD|vdd VDD|vdd sg13_lv_pmos L=0.13u W=1.12u AS=0.3864p
+ AD=0.2128p PS=2.93u PD=1.5u
M$2412 VDD|vdd \$441 A|Q|net15 VDD|vdd sg13_lv_pmos L=0.13u W=1.12u AS=0.2128p
+ AD=0.3808p PS=1.5u PD=2.92u
M$2413 VDD|vdd \$443 \$460 VDD|vdd sg13_lv_pmos L=0.5u W=1u AS=0.2254p AD=0.34p
+ PS=1.53u PD=2.68u
M$2414 A|X|net70 \$460 VDD|vdd VDD|vdd sg13_lv_pmos L=0.13u W=1.12u AS=0.4256p
+ AD=0.2254p PS=3u PD=1.53u
M$2415 VDD|vdd A|Q|net15 \$444 VDD|vdd sg13_lv_pmos L=0.13u W=0.42u AS=0.1523p
+ AD=0.1428p PS=1.38u PD=1.52u
M$2416 \$443 \$444 VDD|vdd VDD|vdd sg13_lv_pmos L=0.5u W=1u AS=0.34p AD=0.1523p
+ PS=2.68u PD=1.38u
M$2417 VDD|vdd \$463 \$462 VDD|vdd sg13_lv_pmos L=0.13u W=0.66u AS=0.4657125p
+ AD=0.2442p PS=2.54u PD=2.06u
M$2418 L_HI|RESET_B|net57 \$461 VDD|vdd VDD|vdd sg13_lv_pmos L=0.13u W=1.155u
+ AS=0.3927p AD=0.4657125p PS=2.99u PD=2.54u
M$2439 VDD|vdd A|Q|net8 \$508 VDD|vdd sg13_lv_pmos L=0.13u W=0.84u AS=0.2114p
+ AD=0.2856p PS=1.54u PD=2.36u
M$2440 BN[3]|X \$508 VDD|vdd VDD|vdd sg13_lv_pmos L=0.13u W=1.12u AS=0.42p
+ AD=0.2114p PS=2.99u PD=1.54u
M$2450 A|Q|net5 \$509 VDD|vdd VDD|vdd sg13_lv_pmos L=0.13u W=1.12u AS=0.3808p
+ AD=0.2128p PS=2.92u PD=1.5u
M$2451 VDD|vdd \$536 \$509 VDD|vdd sg13_lv_pmos L=0.13u W=1.12u AS=0.2128p
+ AD=0.3864p PS=1.5u PD=2.93u
M$2452 VDD|vdd CLK|X|clknet_2_0__leaf_clk \$538 VDD|vdd sg13_lv_pmos L=0.13u
+ W=1.12u AS=0.41165p AD=0.4088p PS=2.12u PD=2.97u
M$2453 VDD|vdd \$538 \$511 VDD|vdd sg13_lv_pmos L=0.13u W=1.12u AS=0.41165p
+ AD=0.3864p PS=2.12u PD=2.93u
M$2454 \$512 \$511 \$513 VDD|vdd sg13_lv_pmos L=0.13u W=0.42u AS=0.1428p
+ AD=0.0798p PS=1.52u PD=0.8u
M$2455 \$513 \$538 \$534 VDD|vdd sg13_lv_pmos L=0.13u W=0.42u AS=0.0798p
+ AD=0.063p PS=0.8u PD=0.72u
M$2456 VDD|vdd \$537 \$534 VDD|vdd sg13_lv_pmos L=0.13u W=0.42u AS=0.1563p
+ AD=0.063p PS=1.22u PD=0.72u
M$2457 VDD|vdd L_HI|RESET_B|net54 \$513 VDD|vdd sg13_lv_pmos L=0.13u W=0.42u
+ AS=0.1563p AD=0.147p PS=1.22u PD=1.54u
M$2458 VDD|vdd \$513 \$537 VDD|vdd sg13_lv_pmos L=0.13u W=1u AS=0.3623875p
+ AD=0.34p PS=2.605u PD=2.68u
M$2459 VDD|vdd L_HI|RESET_B|net54 \$512 VDD|vdd sg13_lv_pmos L=0.13u W=0.42u
+ AS=0.3623875p AD=0.0798p PS=2.605u PD=0.8u
M$2460 \$512 D|Y|_015_ VDD|vdd VDD|vdd sg13_lv_pmos L=0.13u W=0.42u AS=0.0798p
+ AD=0.1428p PS=0.8u PD=1.52u
M$2461 VDD|vdd A1|X|net82 \$551 VDD|vdd sg13_lv_pmos L=0.15u W=1.12u AS=0.3808p
+ AD=0.2128p PS=2.92u PD=1.5u
M$2462 \$551 A1|A2|B|Y|_093_ A|Y|_046_ VDD|vdd sg13_lv_pmos L=0.15u W=1.12u
+ AS=0.2128p AD=0.2128p PS=1.5u PD=1.5u
M$2463 A|Y|_046_ A|B|B1|Y|_068_ VDD|vdd VDD|vdd sg13_lv_pmos L=0.15u W=1.12u
+ AS=0.2128p AD=0.3808p PS=1.5u PD=2.92u
M$2464 D|Y|_000_ A|B1|X|net29 \$515 VDD|vdd sg13_lv_pmos L=0.13u W=1.12u
+ AS=0.3808p AD=0.2128p PS=2.92u PD=1.5u
M$2465 \$515 A1|A2|B_N|Y|_094_ VDD|vdd VDD|vdd sg13_lv_pmos L=0.13u W=1.12u
+ AS=0.2128p AD=0.2128p PS=1.5u PD=1.5u
M$2466 VDD|vdd A2|Y|_095_ \$515 VDD|vdd sg13_lv_pmos L=0.13u W=1.12u AS=0.2128p
+ AD=0.3808p PS=1.5u PD=2.92u
M$2467 VDD|vdd D|Y|_000_ \$517 VDD|vdd sg13_lv_pmos L=0.13u W=0.42u AS=0.1428p
+ AD=0.0798p PS=1.52u PD=0.8u
M$2468 VDD|vdd L_HI|RESET_B|net40 \$517 VDD|vdd sg13_lv_pmos L=0.13u W=0.42u
+ AS=0.3623875p AD=0.0798p PS=2.605u PD=0.8u
M$2469 VDD|vdd \$519 \$518 VDD|vdd sg13_lv_pmos L=0.13u W=1u AS=0.3623875p
+ AD=0.34p PS=2.605u PD=2.68u
M$2470 VDD|vdd L_HI|RESET_B|net40 \$519 VDD|vdd sg13_lv_pmos L=0.13u W=0.42u
+ AS=0.1563p AD=0.147p PS=1.22u PD=1.54u
M$2471 VDD|vdd \$518 \$535 VDD|vdd sg13_lv_pmos L=0.13u W=0.42u AS=0.1563p
+ AD=0.063p PS=1.22u PD=0.72u
M$2472 \$535 \$542 \$519 VDD|vdd sg13_lv_pmos L=0.13u W=0.42u AS=0.063p
+ AD=0.0798p PS=0.72u PD=0.8u
M$2473 \$519 \$520 \$517 VDD|vdd sg13_lv_pmos L=0.13u W=0.42u AS=0.0798p
+ AD=0.1428p PS=0.8u PD=1.52u
M$2474 VDD|vdd \$542 \$520 VDD|vdd sg13_lv_pmos L=0.13u W=1.12u AS=0.41165p
+ AD=0.3864p PS=2.12u PD=2.93u
M$2475 VDD|vdd CLK|X|clknet_2_0__leaf_clk \$542 VDD|vdd sg13_lv_pmos L=0.13u
+ W=1.12u AS=0.41165p AD=0.4088p PS=2.12u PD=2.97u
M$2476 \$518 \$542 \$521 VDD|vdd sg13_lv_pmos L=0.13u W=1u AS=0.34p AD=0.2048p
+ PS=2.68u PD=1.63u
M$2477 \$521 \$520 \$552 VDD|vdd sg13_lv_pmos L=0.13u W=0.42u AS=0.2048p
+ AD=0.09345p PS=1.63u PD=0.865u
M$2478 VDD|vdd \$522 \$552 VDD|vdd sg13_lv_pmos L=0.13u W=0.42u AS=0.204p
+ AD=0.09345p PS=1.835u PD=0.865u
M$2479 VDD|vdd L_HI|RESET_B|net40 \$522 VDD|vdd sg13_lv_pmos L=0.13u W=0.42u
+ AS=0.204p AD=0.0798p PS=1.835u PD=0.8u
M$2480 VDD|vdd \$521 \$522 VDD|vdd sg13_lv_pmos L=0.13u W=0.42u AS=0.4659p
+ AD=0.0798p PS=3.65u PD=0.8u
M$2481 \$523 \$521 VDD|vdd VDD|vdd sg13_lv_pmos L=0.13u W=1.12u AS=0.3864p
+ AD=0.2128p PS=2.93u PD=1.5u
M$2482 VDD|vdd \$523 A|Q|net12 VDD|vdd sg13_lv_pmos L=0.13u W=1.12u AS=0.2128p
+ AD=0.3808p PS=1.5u PD=2.92u
M$2483 VDD|vdd B1|X|net81 A2|Y|_095_ VDD|vdd sg13_lv_pmos L=0.15u W=1.12u
+ AS=0.3808p AD=0.2128p PS=2.92u PD=1.5u
M$2484 A2|Y|_095_ A2|B|C|Y|_092_ \$553 VDD|vdd sg13_lv_pmos L=0.15u W=1.12u
+ AS=0.2128p AD=0.2128p PS=1.5u PD=1.5u
M$2485 \$553 A|A1|Y|_087_ VDD|vdd VDD|vdd sg13_lv_pmos L=0.15u W=1.12u
+ AS=0.2128p AD=0.3808p PS=1.5u PD=2.92u
M$2486 VDD|vdd A1|A2|B|Y|_093_ \$554 VDD|vdd sg13_lv_pmos L=0.15u W=1.12u
+ AS=0.3808p AD=0.2128p PS=2.92u PD=1.5u
M$2487 \$554 A2|D|Y|_038_ A2|Y|_055_ VDD|vdd sg13_lv_pmos L=0.15u W=1.12u
+ AS=0.2128p AD=0.2128p PS=1.5u PD=1.5u
M$2488 A2|Y|_055_ B1|D|X|_048_ VDD|vdd VDD|vdd sg13_lv_pmos L=0.15u W=1.12u
+ AS=0.2128p AD=0.3808p PS=1.5u PD=2.92u
M$2489 VDD|vdd B1|D|X|_048_ A2|Y|_049_ VDD|vdd sg13_lv_pmos L=0.13u W=1.12u
+ AS=0.3808p AD=0.2128p PS=2.92u PD=1.5u
M$2490 A2|Y|_049_ C|Y|_096_ VDD|vdd VDD|vdd sg13_lv_pmos L=0.13u W=1.12u
+ AS=0.2128p AD=0.2128p PS=1.5u PD=1.5u
M$2491 VDD|vdd A2|B|C|D|X|net27 A2|Y|_049_ VDD|vdd sg13_lv_pmos L=0.13u W=1.12u
+ AS=0.2128p AD=0.2128p PS=1.5u PD=1.5u
M$2492 A2|Y|_049_ A|A1|Y|_087_ VDD|vdd VDD|vdd sg13_lv_pmos L=0.13u W=1.12u
+ AS=0.2128p AD=0.3808p PS=1.5u PD=2.92u
M$2493 A1|A2|B|Y|_093_ A2|B|C|Y|_092_ \$555 VDD|vdd sg13_lv_pmos L=0.13u
+ W=1.12u AS=0.3808p AD=0.1176p PS=2.92u PD=1.33u
M$2494 \$555 A|A1|Y|_087_ VDD|vdd VDD|vdd sg13_lv_pmos L=0.13u W=1.12u
+ AS=0.1176p AD=0.4032p PS=1.33u PD=2.96u
M$2498 A2|A_N|B|Y|_035_ A2|B|C|Y|_092_ \$557 VDD|vdd sg13_lv_pmos L=0.13u
+ W=1.12u AS=0.3808p AD=0.2128p PS=2.92u PD=1.5u
M$2499 \$557 A|B|D|X|_085_ \$556 VDD|vdd sg13_lv_pmos L=0.13u W=1.12u
+ AS=0.2128p AD=0.2464p PS=1.5u PD=1.56u
M$2500 \$556 A|Y|_082_ VDD|vdd VDD|vdd sg13_lv_pmos L=0.13u W=1.12u AS=0.2464p
+ AD=0.3808p PS=1.56u PD=2.92u
M$2502 VDD|vdd B|B2|C|Y|_079_ \$507 VDD|vdd sg13_lv_pmos L=0.13u W=0.84u
+ AS=0.36195p AD=0.1596p PS=1.84u PD=1.22u
M$2503 \$507 A|B|B1|Y|_078_ VDD|vdd VDD|vdd sg13_lv_pmos L=0.13u W=0.84u
+ AS=0.1596p AD=0.1596p PS=1.22u PD=1.22u
M$2504 VDD|vdd A|B|Y|_076_ \$507 VDD|vdd sg13_lv_pmos L=0.13u W=0.84u
+ AS=0.1596p AD=0.2856p PS=1.22u PD=2.36u
M$2505 A|B|X|_081_ \$507 VDD|vdd VDD|vdd sg13_lv_pmos L=0.13u W=1.12u
+ AS=0.3808p AD=0.36195p PS=2.92u PD=1.84u
M$2506 VDD|vdd A|clk \$525 VDD|vdd sg13_lv_pmos L=0.13u W=6.72u AS=1.4448p
+ AD=1.2768p PS=10.42u PD=9u
M$2512 VDD|vdd \$525 A|X|clknet_0_clk VDD|vdd sg13_lv_pmos L=0.13u W=17.92u
+ AS=3.4048p AD=3.5896p PS=24u PD=25.45u
M$2533 VDD|vdd \$546 L_HI|RESET_B|net55 VDD|vdd sg13_lv_pmos L=0.13u W=1.155u
+ AS=0.4657125p AD=0.3927p PS=2.54u PD=2.99u
M$2534 VDD|vdd \$548 \$547 VDD|vdd sg13_lv_pmos L=0.13u W=0.66u AS=0.4657125p
+ AD=0.2442p PS=2.54u PD=2.06u
M$2535 B|X|net74 \$528 VDD|vdd VDD|vdd sg13_lv_pmos L=0.13u W=1.12u AS=0.4256p
+ AD=0.2254p PS=3u PD=1.53u
M$2536 VDD|vdd \$529 \$528 VDD|vdd sg13_lv_pmos L=0.5u W=1u AS=0.2254p AD=0.34p
+ PS=1.53u PD=2.68u
M$2537 VDD|vdd A|Q|net16 \$530 VDD|vdd sg13_lv_pmos L=0.13u W=0.42u AS=0.1523p
+ AD=0.1428p PS=1.38u PD=1.52u
M$2538 \$529 \$530 VDD|vdd VDD|vdd sg13_lv_pmos L=0.5u W=1u AS=0.34p AD=0.1523p
+ PS=2.68u PD=1.38u
M$2539 VDD|vdd A|X|net4 \$531 VDD|vdd sg13_lv_pmos L=0.13u W=0.84u AS=0.2114p
+ AD=0.2856p PS=1.54u PD=2.36u
M$2540 A|B1|X|net32 \$531 VDD|vdd VDD|vdd sg13_lv_pmos L=0.13u W=1.12u AS=0.42p
+ AD=0.2114p PS=2.99u PD=1.54u
M$2541 VDD|vdd A|B1|X|net32 \$532 VDD|vdd sg13_lv_pmos L=0.13u W=0.84u
+ AS=0.2114p AD=0.2856p PS=1.54u PD=2.36u
M$2542 A|B1|X|net30 \$532 VDD|vdd VDD|vdd sg13_lv_pmos L=0.13u W=1.12u AS=0.42p
+ AD=0.2114p PS=2.99u PD=1.54u
M$2565 \$533 A|Q|net15 VDD|vdd VDD|vdd sg13_lv_pmos L=0.13u W=0.84u AS=0.2856p
+ AD=0.2114p PS=2.36u PD=1.54u
M$2566 VDD|vdd \$533 B[3]|X VDD|vdd sg13_lv_pmos L=0.13u W=1.12u AS=0.2114p
+ AD=0.42p PS=1.54u PD=2.99u
M$2579 VDD|vdd \$536 \$510 VDD|vdd sg13_lv_pmos L=0.13u W=0.42u AS=0.4659p
+ AD=0.0798p PS=3.65u PD=0.8u
M$2580 VDD|vdd L_HI|RESET_B|net54 \$510 VDD|vdd sg13_lv_pmos L=0.13u W=0.42u
+ AS=0.204p AD=0.0798p PS=1.835u PD=0.8u
M$2581 VDD|vdd \$510 \$550 VDD|vdd sg13_lv_pmos L=0.13u W=0.42u AS=0.204p
+ AD=0.09345p PS=1.835u PD=0.865u
M$2582 \$536 \$511 \$550 VDD|vdd sg13_lv_pmos L=0.13u W=0.42u AS=0.2048p
+ AD=0.09345p PS=1.63u PD=0.865u
M$2583 \$536 \$538 \$537 VDD|vdd sg13_lv_pmos L=0.13u W=1u AS=0.2048p AD=0.34p
+ PS=1.63u PD=2.68u
M$2584 \$602 \$601 VDD|vdd VDD|vdd sg13_lv_pmos L=0.13u W=0.66u AS=0.2442p
+ AD=0.4657125p PS=2.06u PD=2.54u
M$2585 VDD|vdd \$603 L_HI|RESET_B|net54 VDD|vdd sg13_lv_pmos L=0.13u W=1.155u
+ AS=0.4657125p AD=0.3927p PS=2.54u PD=2.99u
M$2587 VDD|vdd A|Q|net5 \$604 VDD|vdd sg13_lv_pmos L=0.13u W=0.42u AS=0.1523p
+ AD=0.1428p PS=1.38u PD=1.52u
M$2588 VDD|vdd \$604 \$605 VDD|vdd sg13_lv_pmos L=0.5u W=1u AS=0.1523p AD=0.34p
+ PS=1.38u PD=2.68u
M$2589 \$606 \$605 VDD|vdd VDD|vdd sg13_lv_pmos L=0.5u W=1u AS=0.34p AD=0.2254p
+ PS=2.68u PD=1.53u
M$2590 VDD|vdd \$606 A1|X|net82 VDD|vdd sg13_lv_pmos L=0.13u W=1.12u AS=0.2254p
+ AD=0.4256p PS=1.53u PD=3u
M$2592 VDD|vdd A1|A2|B|Y|_093_ A1|A2|B_N|Y|_094_ VDD|vdd sg13_lv_pmos L=0.13u
+ W=1.12u AS=0.3808p AD=0.2128p PS=2.92u PD=1.5u
M$2593 A1|A2|B_N|Y|_094_ A|A1|X|net33 VDD|vdd VDD|vdd sg13_lv_pmos L=0.13u
+ W=1.12u AS=0.2128p AD=0.3808p PS=1.5u PD=2.92u
M$2594 \$608 \$607 VDD|vdd VDD|vdd sg13_lv_pmos L=0.13u W=0.66u AS=0.2442p
+ AD=0.4657125p PS=2.06u PD=2.54u
M$2595 VDD|vdd \$609 L_HI|RESET_B|net38 VDD|vdd sg13_lv_pmos L=0.13u W=1.155u
+ AS=0.4657125p AD=0.3927p PS=2.54u PD=2.99u
M$2596 D|Y|_019_ A|B1|X|net29 \$669 VDD|vdd sg13_lv_pmos L=0.13u W=1.12u
+ AS=0.3808p AD=0.2128p PS=2.92u PD=1.5u
M$2597 \$669 A1|Y|_052_ VDD|vdd VDD|vdd sg13_lv_pmos L=0.13u W=1.12u AS=0.2128p
+ AD=0.2128p PS=1.5u PD=1.5u
M$2598 VDD|vdd A2|Y|_053_ \$669 VDD|vdd sg13_lv_pmos L=0.13u W=1.12u AS=0.2128p
+ AD=0.3808p PS=1.5u PD=2.92u
M$2599 VDD|vdd A2|A_N|B|Y|_035_ \$611 VDD|vdd sg13_lv_pmos L=0.13u W=0.84u
+ AS=0.2198p AD=0.2856p PS=1.53u PD=2.36u
M$2600 VDD|vdd \$611 A1|Y|_052_ VDD|vdd sg13_lv_pmos L=0.13u W=1.12u AS=0.3808p
+ AD=0.2128p PS=2.92u PD=1.5u
M$2601 A1|Y|_052_ B|X|net73 VDD|vdd VDD|vdd sg13_lv_pmos L=0.13u W=1.12u
+ AS=0.2128p AD=0.2198p PS=1.5u PD=1.53u
M$2602 VDD|vdd \$659 \$612 VDD|vdd sg13_lv_pmos L=0.5u W=1u AS=0.2254p AD=0.34p
+ PS=1.53u PD=2.68u
M$2603 B|X|net73 \$612 VDD|vdd VDD|vdd sg13_lv_pmos L=0.13u W=1.12u AS=0.4256p
+ AD=0.2254p PS=3u PD=1.53u
M$2604 VDD|vdd A|Q|net9 \$613 VDD|vdd sg13_lv_pmos L=0.13u W=0.42u AS=0.1523p
+ AD=0.1428p PS=1.38u PD=1.52u
M$2605 \$659 \$613 VDD|vdd VDD|vdd sg13_lv_pmos L=0.5u W=1u AS=0.34p AD=0.1523p
+ PS=2.68u PD=1.38u
M$2607 B1|D|X|_048_ \$614 VDD|vdd VDD|vdd sg13_lv_pmos L=0.13u W=1.12u
+ AS=0.3808p AD=0.1918p PS=2.92u PD=1.5u
M$2608 VDD|vdd B|C|D|Y|_097_ \$614 VDD|vdd sg13_lv_pmos L=0.13u W=0.84u
+ AS=0.1918p AD=0.1596p PS=1.5u PD=1.22u
M$2609 \$614 A|A2|X|net2 VDD|vdd VDD|vdd sg13_lv_pmos L=0.13u W=0.84u
+ AS=0.1596p AD=0.2856p PS=1.22u PD=2.36u
M$2610 VDD|vdd A|A1|X|net33 \$615 VDD|vdd sg13_lv_pmos L=0.13u W=0.84u
+ AS=0.2856p AD=0.1596p PS=2.36u PD=1.22u
M$2611 VDD|vdd B|C|D|Y|_097_ \$615 VDD|vdd sg13_lv_pmos L=0.13u W=0.84u
+ AS=0.1918p AD=0.1596p PS=1.5u PD=1.22u
M$2612 VDD|vdd \$615 B1|D|X|_098_ VDD|vdd sg13_lv_pmos L=0.13u W=1.12u
+ AS=0.1918p AD=0.3808p PS=1.5u PD=2.92u
M$2613 VDD|vdd \$661 \$660 VDD|vdd sg13_lv_pmos L=0.5u W=1u AS=0.2254p AD=0.34p
+ PS=1.53u PD=2.68u
M$2614 B1|X|net81 \$660 VDD|vdd VDD|vdd sg13_lv_pmos L=0.13u W=1.12u AS=0.4256p
+ AD=0.2254p PS=3u PD=1.53u
M$2615 VDD|vdd A|Q|net12 \$617 VDD|vdd sg13_lv_pmos L=0.13u W=0.42u AS=0.1523p
+ AD=0.1428p PS=1.38u PD=1.52u
M$2616 \$661 \$617 VDD|vdd VDD|vdd sg13_lv_pmos L=0.5u W=1u AS=0.34p AD=0.1523p
+ PS=2.68u PD=1.38u
M$2617 VDD|vdd A|A1|Y|_087_ A1|A2|Y|_099_ VDD|vdd sg13_lv_pmos L=0.13u W=1.12u
+ AS=0.3808p AD=0.2128p PS=2.92u PD=1.5u
M$2618 A1|A2|Y|_099_ A2|B|C|D|X|net27 VDD|vdd VDD|vdd sg13_lv_pmos L=0.13u
+ W=1.12u AS=0.2128p AD=0.2128p PS=1.5u PD=1.5u
M$2619 VDD|vdd C|Y|_096_ A1|A2|Y|_099_ VDD|vdd sg13_lv_pmos L=0.13u W=1.12u
+ AS=0.2128p AD=0.2128p PS=1.5u PD=1.5u
M$2620 A1|A2|Y|_099_ B1|D|X|_098_ VDD|vdd VDD|vdd sg13_lv_pmos L=0.13u W=1.12u
+ AS=0.2128p AD=0.3808p PS=1.5u PD=2.92u
M$2621 VDD|vdd A|Y|_082_ C|Y|_096_ VDD|vdd sg13_lv_pmos L=0.13u W=1.12u
+ AS=0.3808p AD=0.2128p PS=2.92u PD=1.5u
M$2622 C|Y|_096_ B|C|Y|_086_ VDD|vdd VDD|vdd sg13_lv_pmos L=0.13u W=1.12u
+ AS=0.2128p AD=0.3808p PS=1.5u PD=2.92u
M$2623 VDD|vdd B|C|D|Y|_097_ B|Y|_040_ VDD|vdd sg13_lv_pmos L=0.13u W=1.12u
+ AS=0.3808p AD=0.2128p PS=2.92u PD=1.5u
M$2624 B|Y|_040_ A2|B|C|D|X|net27 VDD|vdd VDD|vdd sg13_lv_pmos L=0.13u W=1.12u
+ AS=0.2128p AD=0.2128p PS=1.5u PD=1.5u
M$2625 VDD|vdd B|C|Y|_086_ B|Y|_040_ VDD|vdd sg13_lv_pmos L=0.13u W=1.12u
+ AS=0.2128p AD=0.2128p PS=1.5u PD=1.5u
M$2626 B|Y|_040_ A|Y|_082_ VDD|vdd VDD|vdd sg13_lv_pmos L=0.13u W=1.12u
+ AS=0.2128p AD=0.3808p PS=1.5u PD=2.92u
M$2627 VDD|vdd A2|B|C|D|X|net27 A2|Y|_053_ VDD|vdd sg13_lv_pmos L=0.13u W=1.12u
+ AS=0.3808p AD=0.2128p PS=2.92u PD=1.5u
M$2628 A2|Y|_053_ B|C|Y|_086_ VDD|vdd VDD|vdd sg13_lv_pmos L=0.13u W=1.12u
+ AS=0.2128p AD=0.2128p PS=1.5u PD=1.5u
M$2629 VDD|vdd A|B|X|_081_ A2|Y|_053_ VDD|vdd sg13_lv_pmos L=0.13u W=1.12u
+ AS=0.2128p AD=0.2128p PS=1.5u PD=1.5u
M$2630 A2|Y|_053_ A|A2|X|net2 VDD|vdd VDD|vdd sg13_lv_pmos L=0.13u W=1.12u
+ AS=0.2128p AD=0.3808p PS=1.5u PD=2.92u
M$2631 A2|D|Y|_038_ A2|B|C|Y|_092_ \$685 VDD|vdd sg13_lv_pmos L=0.13u W=1.12u
+ AS=0.3808p AD=0.2128p PS=2.92u PD=1.5u
M$2632 \$685 A|B|D|X|_085_ \$684 VDD|vdd sg13_lv_pmos L=0.13u W=1.12u
+ AS=0.2128p AD=0.2464p PS=1.5u PD=1.56u
M$2633 \$684 A|B|X|_081_ VDD|vdd VDD|vdd sg13_lv_pmos L=0.13u W=1.12u
+ AS=0.2464p AD=0.3808p PS=1.56u PD=2.92u
M$2634 B|C|Y|_086_ A|B|D|X|_085_ VDD|vdd VDD|vdd sg13_lv_pmos L=0.13u W=1.12u
+ AS=0.3808p AD=0.3808p PS=2.92u PD=2.92u
M$2635 VDD|vdd B|B2|C|Y|_079_ C|Y|_080_ VDD|vdd sg13_lv_pmos L=0.13u W=1.12u
+ AS=0.3808p AD=0.2128p PS=2.92u PD=1.5u
M$2636 C|Y|_080_ A|B|B1|Y|_078_ VDD|vdd VDD|vdd sg13_lv_pmos L=0.13u W=1.12u
+ AS=0.2128p AD=0.3808p PS=1.5u PD=2.92u
M$2637 VDD|vdd A|A2|X|net2 A2|Y|_057_ VDD|vdd sg13_lv_pmos L=0.13u W=1.12u
+ AS=0.3808p AD=0.2128p PS=2.92u PD=1.5u
M$2638 A2|Y|_057_ A|B|Y|_076_ VDD|vdd VDD|vdd sg13_lv_pmos L=0.13u W=1.12u
+ AS=0.2128p AD=0.2128p PS=1.5u PD=1.5u
M$2639 VDD|vdd C|Y|_080_ A2|Y|_057_ VDD|vdd sg13_lv_pmos L=0.13u W=1.12u
+ AS=0.2128p AD=0.2128p PS=1.5u PD=1.5u
M$2640 A2|Y|_057_ A2|D|Y|_038_ VDD|vdd VDD|vdd sg13_lv_pmos L=0.13u W=1.12u
+ AS=0.2128p AD=0.3808p PS=1.5u PD=2.92u
M$2641 VDD|vdd A2|D|Y|_038_ A1|A2|Y|_042_ VDD|vdd sg13_lv_pmos L=0.13u W=1.12u
+ AS=0.3808p AD=0.2128p PS=2.92u PD=1.5u
M$2642 A1|A2|Y|_042_ C|Y|_080_ VDD|vdd VDD|vdd sg13_lv_pmos L=0.13u W=1.12u
+ AS=0.2128p AD=0.2128p PS=1.5u PD=1.5u
M$2643 VDD|vdd A|B|Y|_076_ A1|A2|Y|_042_ VDD|vdd sg13_lv_pmos L=0.13u W=1.12u
+ AS=0.2128p AD=0.2128p PS=1.5u PD=1.5u
M$2644 A1|A2|Y|_042_ A|A1|X|net33 VDD|vdd VDD|vdd sg13_lv_pmos L=0.13u W=1.12u
+ AS=0.2128p AD=0.3808p PS=1.5u PD=2.92u
M$2649 VDD|vdd A|A1|X|net33 A1|Y|_036_ VDD|vdd sg13_lv_pmos L=0.13u W=1.12u
+ AS=0.3808p AD=0.2128p PS=2.92u PD=1.5u
M$2650 A1|Y|_036_ A2|A_N|B|Y|_035_ VDD|vdd VDD|vdd sg13_lv_pmos L=0.13u W=1.12u
+ AS=0.2128p AD=0.3808p PS=1.5u PD=2.92u
M$2651 \$620 A2|A_N|B|Y|_035_ VDD|vdd VDD|vdd sg13_lv_pmos L=0.13u W=0.84u
+ AS=0.2856p AD=0.2198p PS=2.36u PD=1.53u
M$2652 VDD|vdd B|X|net74 A2|Y|_037_ VDD|vdd sg13_lv_pmos L=0.13u W=1.12u
+ AS=0.2198p AD=0.2128p PS=1.53u PD=1.5u
M$2653 A2|Y|_037_ \$620 VDD|vdd VDD|vdd sg13_lv_pmos L=0.13u W=1.12u AS=0.2128p
+ AD=0.3808p PS=1.5u PD=2.92u
M$2654 \$672 A2|Y|_037_ VDD|vdd VDD|vdd sg13_lv_pmos L=0.13u W=1.12u AS=0.3808p
+ AD=0.2128p PS=2.92u PD=1.5u
M$2655 VDD|vdd A1|Y|_036_ \$672 VDD|vdd sg13_lv_pmos L=0.13u W=1.12u AS=0.2128p
+ AD=0.2128p PS=1.5u PD=1.5u
M$2656 \$672 A|B1|X|net30 D|Y|_004_ VDD|vdd sg13_lv_pmos L=0.13u W=1.12u
+ AS=0.2128p AD=0.3808p PS=1.5u PD=2.92u
M$2657 VDD|vdd D|Y|_004_ \$593 VDD|vdd sg13_lv_pmos L=0.13u W=0.42u AS=0.1428p
+ AD=0.0798p PS=1.52u PD=0.8u
M$2658 VDD|vdd L_HI|RESET_B|net53 \$593 VDD|vdd sg13_lv_pmos L=0.13u W=0.42u
+ AS=0.3623875p AD=0.0798p PS=2.605u PD=0.8u
M$2659 VDD|vdd \$663 \$594 VDD|vdd sg13_lv_pmos L=0.13u W=1u AS=0.3623875p
+ AD=0.34p PS=2.605u PD=2.68u
M$2660 \$673 \$595 VDD|vdd VDD|vdd sg13_lv_pmos L=0.13u W=1.12u AS=0.3864p
+ AD=0.41165p PS=2.93u PD=2.12u
M$2661 VDD|vdd CLK|X|clknet_2_2__leaf_clk \$595 VDD|vdd sg13_lv_pmos L=0.13u
+ W=1.12u AS=0.41165p AD=0.4088p PS=2.12u PD=2.97u
M$2662 \$623 \$673 \$683 VDD|vdd sg13_lv_pmos L=0.13u W=0.42u AS=0.2048p
+ AD=0.09345p PS=1.63u PD=0.865u
M$2663 \$683 \$597 VDD|vdd VDD|vdd sg13_lv_pmos L=0.13u W=0.42u AS=0.09345p
+ AD=0.204p PS=0.865u PD=1.835u
M$2664 VDD|vdd L_HI|RESET_B|net53 \$597 VDD|vdd sg13_lv_pmos L=0.13u W=0.42u
+ AS=0.204p AD=0.0798p PS=1.835u PD=0.8u
M$2665 \$597 \$623 VDD|vdd VDD|vdd sg13_lv_pmos L=0.13u W=0.42u AS=0.0798p
+ AD=0.4659p PS=0.8u PD=3.65u
M$2666 \$594 \$595 \$623 VDD|vdd sg13_lv_pmos L=0.13u W=1u AS=0.34p AD=0.2048p
+ PS=2.68u PD=1.63u
M$2667 \$598 \$623 VDD|vdd VDD|vdd sg13_lv_pmos L=0.13u W=1.12u AS=0.3864p
+ AD=0.2128p PS=2.93u PD=1.5u
M$2668 VDD|vdd \$598 A|Q|net16 VDD|vdd sg13_lv_pmos L=0.13u W=1.12u AS=0.2128p
+ AD=0.3808p PS=1.5u PD=2.92u
M$2670 VDD|vdd A|B1|X|net32 \$624 VDD|vdd sg13_lv_pmos L=0.13u W=0.84u
+ AS=0.2114p AD=0.2856p PS=1.54u PD=2.36u
M$2671 VDD|vdd \$624 A|B1|X|net31 VDD|vdd sg13_lv_pmos L=0.13u W=1.12u
+ AS=0.2114p AD=0.42p PS=1.54u PD=2.99u
M$2672 VDD|vdd B|Y|_043_ A2|Y|_044_ VDD|vdd sg13_lv_pmos L=0.13u W=1.12u
+ AS=0.3808p AD=0.2128p PS=2.92u PD=1.5u
M$2673 A2|Y|_044_ A|X|net67 VDD|vdd VDD|vdd sg13_lv_pmos L=0.13u W=1.12u
+ AS=0.2128p AD=0.3808p PS=1.5u PD=2.92u
M$2675 VDD|vdd \$627 \$626 VDD|vdd sg13_lv_pmos L=0.13u W=0.66u AS=0.4657125p
+ AD=0.2442p PS=2.54u PD=2.06u
M$2676 L_HI|RESET_B|net49 \$625 VDD|vdd VDD|vdd sg13_lv_pmos L=0.13u W=1.155u
+ AS=0.3927p AD=0.4657125p PS=2.99u PD=2.54u
M$2678 VDD|vdd \$667 \$666 VDD|vdd sg13_lv_pmos L=0.5u W=1u AS=0.2254p AD=0.34p
+ PS=1.53u PD=2.68u
M$2679 A|X|net67 \$666 VDD|vdd VDD|vdd sg13_lv_pmos L=0.13u W=1.12u AS=0.4256p
+ AD=0.2254p PS=3u PD=1.53u
M$2680 VDD|vdd A|Q|net18 \$628 VDD|vdd sg13_lv_pmos L=0.13u W=0.42u AS=0.1523p
+ AD=0.1428p PS=1.38u PD=1.52u
M$2681 \$667 \$628 VDD|vdd VDD|vdd sg13_lv_pmos L=0.5u W=1u AS=0.34p AD=0.1523p
+ PS=2.68u PD=1.38u
M$2695 VDD|vdd A|Q|net9 \$694 VDD|vdd sg13_lv_pmos L=0.13u W=0.84u AS=0.2114p
+ AD=0.2856p PS=1.54u PD=2.36u
M$2696 BN[4]|X \$694 VDD|vdd VDD|vdd sg13_lv_pmos L=0.13u W=1.12u AS=0.42p
+ AD=0.2114p PS=2.99u PD=1.54u
M$2708 VDD|vdd \$729 L_HI|RESET_B|net47 VDD|vdd sg13_lv_pmos L=0.13u W=1.155u
+ AS=0.4657125p AD=0.3927p PS=2.54u PD=2.99u
M$2709 VDD|vdd \$731 \$730 VDD|vdd sg13_lv_pmos L=0.13u W=0.66u AS=0.4657125p
+ AD=0.2442p PS=2.54u PD=2.06u
M$2712 \$695 A1|A2|B_N|Y|_094_ VDD|vdd VDD|vdd sg13_lv_pmos L=0.13u W=1.12u
+ AS=0.3808p AD=0.2128p PS=2.92u PD=1.5u
M$2713 VDD|vdd A1|Y|_067_ \$695 VDD|vdd sg13_lv_pmos L=0.13u W=1.12u AS=0.2128p
+ AD=0.2128p PS=1.5u PD=1.5u
M$2714 \$695 A|B1|X|net29 D|Y|_007_ VDD|vdd sg13_lv_pmos L=0.13u W=1.12u
+ AS=0.2128p AD=0.3808p PS=1.5u PD=2.92u
M$2717 \$703 \$701 VDD|vdd VDD|vdd sg13_lv_pmos L=0.13u W=1.12u AS=0.3864p
+ AD=0.2128p PS=2.93u PD=1.5u
M$2718 VDD|vdd \$703 A|Q|net9 VDD|vdd sg13_lv_pmos L=0.13u W=1.12u AS=0.2128p
+ AD=0.3808p PS=1.5u PD=2.92u
M$2719 VDD|vdd A|CLK|X|clknet_2_1__leaf_clk Y VDD|vdd sg13_lv_pmos L=0.13u
+ W=1.12u AS=0.3808p AD=0.3808p PS=2.92u PD=2.92u
M$2720 VDD|vdd \$690 A|CLK|X|clknet_2_1__leaf_clk VDD|vdd sg13_lv_pmos L=0.13u
+ W=17.92u AS=3.5896p AD=3.4048p PS=25.45u PD=24u
M$2736 VDD|vdd A|X|clknet_0_clk \$690 VDD|vdd sg13_lv_pmos L=0.13u W=6.72u
+ AS=1.2768p AD=1.4448p PS=9u PD=10.42u
M$2742 VDD|vdd A1|A2|B|Y|_093_ \$747 VDD|vdd sg13_lv_pmos L=0.15u W=1.12u
+ AS=0.3808p AD=0.2128p PS=2.92u PD=1.5u
M$2743 \$747 A2|D|Y|_038_ A1|A2|Y|_039_ VDD|vdd sg13_lv_pmos L=0.15u W=1.12u
+ AS=0.2128p AD=0.2128p PS=1.5u PD=1.5u
M$2744 A1|A2|Y|_039_ B1|D|X|_098_ VDD|vdd VDD|vdd sg13_lv_pmos L=0.15u W=1.12u
+ AS=0.2128p AD=0.3808p PS=1.5u PD=2.92u
M$2752 VDD|vdd B|Y|_043_ A1|Y|_056_ VDD|vdd sg13_lv_pmos L=0.13u W=1.12u
+ AS=0.3808p AD=0.2128p PS=2.92u PD=1.5u
M$2753 A1|Y|_056_ A|X|net77 VDD|vdd VDD|vdd sg13_lv_pmos L=0.13u W=1.12u
+ AS=0.2128p AD=0.3808p PS=1.5u PD=2.92u
M$2754 VDD|vdd A|Y|_082_ B|Y|_043_ VDD|vdd sg13_lv_pmos L=0.13u W=1.12u
+ AS=0.3808p AD=0.2128p PS=2.92u PD=1.5u
M$2755 B|Y|_043_ B|C|Y|_086_ VDD|vdd VDD|vdd sg13_lv_pmos L=0.13u W=1.12u
+ AS=0.2128p AD=0.2128p PS=1.5u PD=1.5u
M$2756 VDD|vdd A|B|C|X|_091_ B|Y|_043_ VDD|vdd sg13_lv_pmos L=0.13u W=1.12u
+ AS=0.2128p AD=0.2128p PS=1.5u PD=1.5u
M$2757 B|Y|_043_ C|D|Y|_026_ VDD|vdd VDD|vdd sg13_lv_pmos L=0.13u W=1.12u
+ AS=0.2128p AD=0.3808p PS=1.5u PD=2.92u
M$2758 A|X|net77 \$706 VDD|vdd VDD|vdd sg13_lv_pmos L=0.13u W=1.12u AS=0.4256p
+ AD=0.2254p PS=3u PD=1.53u
M$2759 VDD|vdd \$707 \$706 VDD|vdd sg13_lv_pmos L=0.5u W=1u AS=0.2254p AD=0.34p
+ PS=1.53u PD=2.68u
M$2760 VDD|vdd A|Q|net11 \$708 VDD|vdd sg13_lv_pmos L=0.13u W=0.42u AS=0.1523p
+ AD=0.1428p PS=1.38u PD=1.52u
M$2761 \$707 \$708 VDD|vdd VDD|vdd sg13_lv_pmos L=0.5u W=1u AS=0.34p AD=0.1523p
+ PS=2.68u PD=1.38u
M$2762 \$709 A2|A_N|B|Y|_035_ VDD|vdd VDD|vdd sg13_lv_pmos L=0.13u W=1.12u
+ AS=0.3808p AD=0.2128p PS=2.92u PD=1.5u
M$2763 VDD|vdd A|A1|X|net3 \$709 VDD|vdd sg13_lv_pmos L=0.13u W=1.12u
+ AS=0.2128p AD=0.2128p PS=1.5u PD=1.5u
M$2764 \$709 B1|X|net60 B|Y|_045_ VDD|vdd sg13_lv_pmos L=0.13u W=1.12u
+ AS=0.2128p AD=0.3808p PS=1.5u PD=2.92u
M$2770 VDD|vdd B|Y|_040_ A2|Y|_041_ VDD|vdd sg13_lv_pmos L=0.13u W=1.12u
+ AS=0.3808p AD=0.2128p PS=2.92u PD=1.5u
M$2771 A2|Y|_041_ A|X|net72 VDD|vdd VDD|vdd sg13_lv_pmos L=0.13u W=1.12u
+ AS=0.2128p AD=0.3808p PS=1.5u PD=2.92u
M$2772 \$663 L_HI|RESET_B|net53 VDD|vdd VDD|vdd sg13_lv_pmos L=0.13u W=0.42u
+ AS=0.147p AD=0.1563p PS=1.54u PD=1.22u
M$2773 VDD|vdd \$594 \$688 VDD|vdd sg13_lv_pmos L=0.13u W=0.42u AS=0.1563p
+ AD=0.063p PS=1.22u PD=0.72u
M$2774 \$688 \$595 \$663 VDD|vdd sg13_lv_pmos L=0.13u W=0.42u AS=0.063p
+ AD=0.0798p PS=0.72u PD=0.8u
M$2775 \$663 \$673 \$593 VDD|vdd sg13_lv_pmos L=0.13u W=0.42u AS=0.0798p
+ AD=0.1428p PS=0.8u PD=1.52u
M$2776 VDD|vdd \$740 L_HI|RESET_B|net53 VDD|vdd sg13_lv_pmos L=0.13u W=1.155u
+ AS=0.4657125p AD=0.3927p PS=2.54u PD=2.99u
M$2777 VDD|vdd \$742 \$741 VDD|vdd sg13_lv_pmos L=0.13u W=0.66u AS=0.4657125p
+ AD=0.2442p PS=2.54u PD=2.06u
M$2778 VDD|vdd A|X|clknet_0_clk \$712 VDD|vdd sg13_lv_pmos L=0.13u W=6.72u
+ AS=1.4448p AD=1.2768p PS=10.42u PD=9u
M$2784 VDD|vdd \$712 A|CLK|X|clknet_2_3__leaf_clk VDD|vdd sg13_lv_pmos L=0.13u
+ W=17.92u AS=3.4048p AD=3.5896p PS=24u PD=25.45u
M$2800 D|Y|_006_ A|B1|X|net31 \$715 VDD|vdd sg13_lv_pmos L=0.13u W=1.12u
+ AS=0.3808p AD=0.2128p PS=2.92u PD=1.5u
M$2801 \$715 A1|A2|Y|_042_ VDD|vdd VDD|vdd sg13_lv_pmos L=0.13u W=1.12u
+ AS=0.2128p AD=0.2128p PS=1.5u PD=1.5u
M$2802 VDD|vdd A2|Y|_044_ \$715 VDD|vdd sg13_lv_pmos L=0.13u W=1.12u AS=0.2128p
+ AD=0.3808p PS=1.5u PD=2.92u
M$2803 \$722 \$720 VDD|vdd VDD|vdd sg13_lv_pmos L=0.13u W=1.12u AS=0.3864p
+ AD=0.2128p PS=2.93u PD=1.5u
M$2804 VDD|vdd \$722 A|Q|net18 VDD|vdd sg13_lv_pmos L=0.13u W=1.12u AS=0.2128p
+ AD=0.3808p PS=1.5u PD=2.92u
M$2816 \$724 A|Q|net16 VDD|vdd VDD|vdd sg13_lv_pmos L=0.13u W=0.84u AS=0.2856p
+ AD=0.2114p PS=2.36u PD=1.54u
M$2817 VDD|vdd \$724 B[4]|X VDD|vdd sg13_lv_pmos L=0.13u W=1.12u AS=0.2114p
+ AD=0.42p PS=1.54u PD=2.99u
M$2818 VDD|vdd D|Y|_007_ \$770 VDD|vdd sg13_lv_pmos L=0.13u W=0.42u AS=0.1428p
+ AD=0.0798p PS=1.52u PD=0.8u
M$2819 VDD|vdd L_HI|RESET_B|net47 \$770 VDD|vdd sg13_lv_pmos L=0.13u W=0.42u
+ AS=0.3623875p AD=0.0798p PS=2.605u PD=0.8u
M$2820 VDD|vdd \$849 \$771 VDD|vdd sg13_lv_pmos L=0.13u W=1u AS=0.3623875p
+ AD=0.34p PS=2.605u PD=2.68u
M$2821 \$869 \$772 VDD|vdd VDD|vdd sg13_lv_pmos L=0.13u W=1.12u AS=0.3864p
+ AD=0.41165p PS=2.93u PD=2.12u
M$2822 VDD|vdd A|CLK|X|clknet_2_1__leaf_clk \$772 VDD|vdd sg13_lv_pmos L=0.13u
+ W=1.12u AS=0.41165p AD=0.4088p PS=2.12u PD=2.97u
M$2823 \$805 \$869 \$881 VDD|vdd sg13_lv_pmos L=0.13u W=0.42u AS=0.2048p
+ AD=0.09345p PS=1.63u PD=0.865u
M$2824 \$881 \$774 VDD|vdd VDD|vdd sg13_lv_pmos L=0.13u W=0.42u AS=0.09345p
+ AD=0.204p PS=0.865u PD=1.835u
M$2825 VDD|vdd L_HI|RESET_B|net47 \$774 VDD|vdd sg13_lv_pmos L=0.13u W=0.42u
+ AS=0.204p AD=0.0798p PS=1.835u PD=0.8u
M$2826 \$774 \$805 VDD|vdd VDD|vdd sg13_lv_pmos L=0.13u W=0.42u AS=0.0798p
+ AD=0.4659p PS=0.8u PD=3.65u
M$2827 \$771 \$772 \$805 VDD|vdd sg13_lv_pmos L=0.13u W=1u AS=0.34p AD=0.2048p
+ PS=2.68u PD=1.63u
M$2828 \$775 \$805 VDD|vdd VDD|vdd sg13_lv_pmos L=0.13u W=1.12u AS=0.3864p
+ AD=0.2128p PS=2.93u PD=1.5u
M$2829 VDD|vdd \$775 A|Q|net19 VDD|vdd sg13_lv_pmos L=0.13u W=1.12u AS=0.2128p
+ AD=0.3808p PS=1.5u PD=2.92u
M$2830 A1|Y|_067_ A|X|net66 VDD|vdd VDD|vdd sg13_lv_pmos L=0.13u W=1.12u
+ AS=0.3808p AD=0.3808p PS=2.92u PD=2.92u
M$2831 A1|Y|_066_ A|X|net65 VDD|vdd VDD|vdd sg13_lv_pmos L=0.13u W=1.12u
+ AS=0.3808p AD=0.3808p PS=2.92u PD=2.92u
M$2832 VDD|vdd D|Y|_019_ \$697 VDD|vdd sg13_lv_pmos L=0.13u W=0.42u AS=0.1428p
+ AD=0.0798p PS=1.52u PD=0.8u
M$2833 VDD|vdd L_HI|RESET_B|net38 \$697 VDD|vdd sg13_lv_pmos L=0.13u W=0.42u
+ AS=0.3623875p AD=0.0798p PS=2.605u PD=0.8u
M$2834 VDD|vdd \$699 \$698 VDD|vdd sg13_lv_pmos L=0.13u W=1u AS=0.3623875p
+ AD=0.34p PS=2.605u PD=2.68u
M$2835 VDD|vdd D|Y|_009_ \$777 VDD|vdd sg13_lv_pmos L=0.13u W=0.42u AS=0.1428p
+ AD=0.0798p PS=1.52u PD=0.8u
M$2836 VDD|vdd L_HI|RESET_B|net43 \$777 VDD|vdd sg13_lv_pmos L=0.13u W=0.42u
+ AS=0.3623875p AD=0.0798p PS=2.605u PD=0.8u
M$2837 VDD|vdd \$854 \$778 VDD|vdd sg13_lv_pmos L=0.13u W=1u AS=0.3623875p
+ AD=0.34p PS=2.605u PD=2.68u
M$2838 VDD|vdd L_HI|RESET_B|net38 \$699 VDD|vdd sg13_lv_pmos L=0.13u W=0.42u
+ AS=0.1563p AD=0.147p PS=1.22u PD=1.54u
M$2839 VDD|vdd \$698 \$727 VDD|vdd sg13_lv_pmos L=0.13u W=0.42u AS=0.1563p
+ AD=0.063p PS=1.22u PD=0.72u
M$2840 \$727 \$734 \$699 VDD|vdd sg13_lv_pmos L=0.13u W=0.42u AS=0.063p
+ AD=0.0798p PS=0.72u PD=0.8u
M$2841 \$699 \$700 \$697 VDD|vdd sg13_lv_pmos L=0.13u W=0.42u AS=0.0798p
+ AD=0.1428p PS=0.8u PD=1.52u
M$2842 VDD|vdd \$734 \$700 VDD|vdd sg13_lv_pmos L=0.13u W=1.12u AS=0.41165p
+ AD=0.3864p PS=2.12u PD=2.93u
M$2843 VDD|vdd A|CLK|X|clknet_2_1__leaf_clk \$734 VDD|vdd sg13_lv_pmos L=0.13u
+ W=1.12u AS=0.41165p AD=0.4088p PS=2.12u PD=2.97u
M$2844 \$870 \$779 VDD|vdd VDD|vdd sg13_lv_pmos L=0.13u W=1.12u AS=0.3864p
+ AD=0.41165p PS=2.93u PD=2.12u
M$2845 VDD|vdd A|CLK|X|clknet_2_1__leaf_clk \$779 VDD|vdd sg13_lv_pmos L=0.13u
+ W=1.12u AS=0.41165p AD=0.4088p PS=2.12u PD=2.97u
M$2846 \$698 \$734 \$701 VDD|vdd sg13_lv_pmos L=0.13u W=1u AS=0.34p AD=0.2048p
+ PS=2.68u PD=1.63u
M$2847 \$701 \$700 \$745 VDD|vdd sg13_lv_pmos L=0.13u W=0.42u AS=0.2048p
+ AD=0.09345p PS=1.63u PD=0.865u
M$2848 VDD|vdd \$702 \$745 VDD|vdd sg13_lv_pmos L=0.13u W=0.42u AS=0.204p
+ AD=0.09345p PS=1.835u PD=0.865u
M$2849 VDD|vdd L_HI|RESET_B|net38 \$702 VDD|vdd sg13_lv_pmos L=0.13u W=0.42u
+ AS=0.204p AD=0.0798p PS=1.835u PD=0.8u
M$2850 VDD|vdd \$701 \$702 VDD|vdd sg13_lv_pmos L=0.13u W=0.42u AS=0.4659p
+ AD=0.0798p PS=3.65u PD=0.8u
M$2851 \$808 \$870 \$883 VDD|vdd sg13_lv_pmos L=0.13u W=0.42u AS=0.2048p
+ AD=0.09345p PS=1.63u PD=0.865u
M$2852 \$883 \$781 VDD|vdd VDD|vdd sg13_lv_pmos L=0.13u W=0.42u AS=0.09345p
+ AD=0.204p PS=0.865u PD=1.835u
M$2853 VDD|vdd L_HI|RESET_B|net43 \$781 VDD|vdd sg13_lv_pmos L=0.13u W=0.42u
+ AS=0.204p AD=0.0798p PS=1.835u PD=0.8u
M$2854 \$781 \$808 VDD|vdd VDD|vdd sg13_lv_pmos L=0.13u W=0.42u AS=0.0798p
+ AD=0.4659p PS=0.8u PD=3.65u
M$2855 \$778 \$779 \$808 VDD|vdd sg13_lv_pmos L=0.13u W=1u AS=0.34p AD=0.2048p
+ PS=2.68u PD=1.63u
M$2856 \$782 \$808 VDD|vdd VDD|vdd sg13_lv_pmos L=0.13u W=1.12u AS=0.3864p
+ AD=0.2128p PS=2.93u PD=1.5u
M$2857 VDD|vdd \$782 A|Q|net21 VDD|vdd sg13_lv_pmos L=0.13u W=1.12u AS=0.2128p
+ AD=0.3808p PS=1.5u PD=2.92u
M$2858 VDD|vdd A|Q|net10 \$809 VDD|vdd sg13_lv_pmos L=0.13u W=0.42u AS=0.1523p
+ AD=0.1428p PS=1.38u PD=1.52u
M$2859 VDD|vdd \$809 \$810 VDD|vdd sg13_lv_pmos L=0.5u W=1u AS=0.1523p AD=0.34p
+ PS=1.38u PD=2.68u
M$2860 \$811 \$810 VDD|vdd VDD|vdd sg13_lv_pmos L=0.5u W=1u AS=0.34p AD=0.2254p
+ PS=2.68u PD=1.53u
M$2861 VDD|vdd \$811 A|X|net68 VDD|vdd sg13_lv_pmos L=0.13u W=1.12u AS=0.2254p
+ AD=0.4256p PS=1.53u PD=3u
M$2862 D|Y|_020_ A|B1|X|net32 \$871 VDD|vdd sg13_lv_pmos L=0.13u W=1.12u
+ AS=0.3808p AD=0.2128p PS=2.92u PD=1.5u
M$2863 \$871 A1|Y|_054_ VDD|vdd VDD|vdd sg13_lv_pmos L=0.13u W=1.12u AS=0.2128p
+ AD=0.2128p PS=1.5u PD=1.5u
M$2864 VDD|vdd A2|Y|_055_ \$871 VDD|vdd sg13_lv_pmos L=0.13u W=1.12u AS=0.2128p
+ AD=0.3808p PS=1.5u PD=2.92u
M$2865 VDD|vdd A|X|net68 A1|Y|_054_ VDD|vdd sg13_lv_pmos L=0.13u W=1.12u
+ AS=0.3808p AD=0.2128p PS=2.92u PD=1.5u
M$2866 A1|Y|_054_ B|Y|_040_ VDD|vdd VDD|vdd sg13_lv_pmos L=0.13u W=1.12u
+ AS=0.2128p AD=0.3808p PS=1.5u PD=2.92u
M$2868 D|Y|_010_ A|B1|X|net29 \$872 VDD|vdd sg13_lv_pmos L=0.13u W=1.12u
+ AS=0.3808p AD=0.2128p PS=2.92u PD=1.5u
M$2869 \$872 A1|Y|_064_ VDD|vdd VDD|vdd sg13_lv_pmos L=0.13u W=1.12u AS=0.2128p
+ AD=0.2128p PS=1.5u PD=1.5u
M$2870 VDD|vdd A1|A2|Y|_031_ \$872 VDD|vdd sg13_lv_pmos L=0.13u W=1.12u
+ AS=0.2128p AD=0.3808p PS=1.5u PD=2.92u
M$2871 A1|Y|_064_ A|X|net63 VDD|vdd VDD|vdd sg13_lv_pmos L=0.13u W=1.12u
+ AS=0.3808p AD=0.3808p PS=2.92u PD=2.92u
M$2873 VDD|vdd D|Y|_021_ \$784 VDD|vdd sg13_lv_pmos L=0.13u W=0.42u AS=0.1428p
+ AD=0.0798p PS=1.52u PD=0.8u
M$2874 VDD|vdd L_HI|RESET_B|net52 \$784 VDD|vdd sg13_lv_pmos L=0.13u W=0.42u
+ AS=0.3623875p AD=0.0798p PS=2.605u PD=0.8u
M$2875 VDD|vdd \$859 \$785 VDD|vdd sg13_lv_pmos L=0.13u W=1u AS=0.3623875p
+ AD=0.34p PS=2.605u PD=2.68u
M$2876 \$873 \$786 VDD|vdd VDD|vdd sg13_lv_pmos L=0.13u W=1.12u AS=0.3864p
+ AD=0.41165p PS=2.93u PD=2.12u
M$2877 VDD|vdd A|CLK|X|clknet_2_3__leaf_clk \$786 VDD|vdd sg13_lv_pmos L=0.13u
+ W=1.12u AS=0.41165p AD=0.4088p PS=2.12u PD=2.97u
M$2878 \$817 \$873 \$882 VDD|vdd sg13_lv_pmos L=0.13u W=0.42u AS=0.2048p
+ AD=0.09345p PS=1.63u PD=0.865u
M$2879 \$882 \$788 VDD|vdd VDD|vdd sg13_lv_pmos L=0.13u W=0.42u AS=0.09345p
+ AD=0.204p PS=0.865u PD=1.835u
M$2880 VDD|vdd L_HI|RESET_B|net52 \$788 VDD|vdd sg13_lv_pmos L=0.13u W=0.42u
+ AS=0.204p AD=0.0798p PS=1.835u PD=0.8u
M$2881 \$788 \$817 VDD|vdd VDD|vdd sg13_lv_pmos L=0.13u W=0.42u AS=0.0798p
+ AD=0.4659p PS=0.8u PD=3.65u
M$2882 \$785 \$786 \$817 VDD|vdd sg13_lv_pmos L=0.13u W=1u AS=0.34p AD=0.2048p
+ PS=2.68u PD=1.63u
M$2883 \$789 \$817 VDD|vdd VDD|vdd sg13_lv_pmos L=0.13u W=1.12u AS=0.3864p
+ AD=0.2128p PS=2.93u PD=1.5u
M$2884 VDD|vdd \$789 A|Q|net11 VDD|vdd sg13_lv_pmos L=0.13u W=1.12u AS=0.2128p
+ AD=0.3808p PS=1.5u PD=2.92u
M$2885 VDD|vdd A|B1|X|net30 \$899 VDD|vdd sg13_lv_pmos L=0.13u W=1.12u
+ AS=0.4032p AD=0.1176p PS=2.96u PD=1.33u
M$2886 \$899 B|Y|_045_ D|Y|_011_ VDD|vdd sg13_lv_pmos L=0.13u W=1.12u
+ AS=0.1176p AD=0.3808p PS=1.33u PD=2.92u
M$2888 VDD|vdd \$861 \$819 VDD|vdd sg13_lv_pmos L=0.5u W=1u AS=0.2254p AD=0.34p
+ PS=1.53u PD=2.68u
M$2889 B1|X|net60 \$819 VDD|vdd VDD|vdd sg13_lv_pmos L=0.13u W=1.12u AS=0.4256p
+ AD=0.2254p PS=3u PD=1.53u
M$2890 VDD|vdd A|Q|net23 \$820 VDD|vdd sg13_lv_pmos L=0.13u W=0.42u AS=0.1523p
+ AD=0.1428p PS=1.38u PD=1.52u
M$2891 \$861 \$820 VDD|vdd VDD|vdd sg13_lv_pmos L=0.5u W=1u AS=0.34p AD=0.1523p
+ PS=2.68u PD=1.38u
M$2892 \$874 A2|Y|_041_ VDD|vdd VDD|vdd sg13_lv_pmos L=0.13u W=1.12u AS=0.3808p
+ AD=0.2128p PS=2.92u PD=1.5u
M$2893 VDD|vdd A1|A2|Y|_039_ \$874 VDD|vdd sg13_lv_pmos L=0.13u W=1.12u
+ AS=0.2128p AD=0.2128p PS=1.5u PD=1.5u
M$2894 \$874 A|B1|X|net31 D|Y|_005_ VDD|vdd sg13_lv_pmos L=0.13u W=1.12u
+ AS=0.2128p AD=0.3808p PS=1.5u PD=2.92u
M$2895 \$875 A1|A2|Y|_039_ VDD|vdd VDD|vdd sg13_lv_pmos L=0.13u W=1.12u
+ AS=0.3808p AD=0.2128p PS=2.92u PD=1.5u
M$2896 VDD|vdd A1|Y|_063_ \$875 VDD|vdd sg13_lv_pmos L=0.13u W=1.12u AS=0.2128p
+ AD=0.2128p PS=1.5u PD=1.5u
M$2897 \$875 A|B1|X|net30 D|Y|_012_ VDD|vdd sg13_lv_pmos L=0.13u W=1.12u
+ AS=0.2128p AD=0.3808p PS=1.5u PD=2.92u
M$2898 VDD|vdd D|Y|_005_ \$790 VDD|vdd sg13_lv_pmos L=0.13u W=0.42u AS=0.1428p
+ AD=0.0798p PS=1.52u PD=0.8u
M$2899 VDD|vdd L_HI|RESET_B|net51 \$790 VDD|vdd sg13_lv_pmos L=0.13u W=0.42u
+ AS=0.3623875p AD=0.0798p PS=2.605u PD=0.8u
M$2900 VDD|vdd \$863 \$791 VDD|vdd sg13_lv_pmos L=0.13u W=1u AS=0.3623875p
+ AD=0.34p PS=2.605u PD=2.68u
M$2901 \$876 \$792 VDD|vdd VDD|vdd sg13_lv_pmos L=0.13u W=1.12u AS=0.3864p
+ AD=0.41165p PS=2.93u PD=2.12u
M$2902 VDD|vdd CLK|X|clknet_2_2__leaf_clk \$792 VDD|vdd sg13_lv_pmos L=0.13u
+ W=1.12u AS=0.41165p AD=0.4088p PS=2.12u PD=2.97u
M$2903 \$824 \$876 \$880 VDD|vdd sg13_lv_pmos L=0.13u W=0.42u AS=0.2048p
+ AD=0.09345p PS=1.63u PD=0.865u
M$2904 \$880 \$794 VDD|vdd VDD|vdd sg13_lv_pmos L=0.13u W=0.42u AS=0.09345p
+ AD=0.204p PS=0.865u PD=1.835u
M$2905 VDD|vdd L_HI|RESET_B|net51 \$794 VDD|vdd sg13_lv_pmos L=0.13u W=0.42u
+ AS=0.204p AD=0.0798p PS=1.835u PD=0.8u
M$2906 \$794 \$824 VDD|vdd VDD|vdd sg13_lv_pmos L=0.13u W=0.42u AS=0.0798p
+ AD=0.4659p PS=0.8u PD=3.65u
M$2907 \$791 \$792 \$824 VDD|vdd sg13_lv_pmos L=0.13u W=1u AS=0.34p AD=0.2048p
+ PS=2.68u PD=1.63u
M$2908 \$795 \$824 VDD|vdd VDD|vdd sg13_lv_pmos L=0.13u W=1.12u AS=0.3864p
+ AD=0.2128p PS=2.93u PD=1.5u
M$2909 VDD|vdd \$795 A|Q|net17 VDD|vdd sg13_lv_pmos L=0.13u W=1.12u AS=0.2128p
+ AD=0.3808p PS=1.5u PD=2.92u
M$2911 D|Y|_013_ A|B1|X|net31 \$877 VDD|vdd sg13_lv_pmos L=0.13u W=1.12u
+ AS=0.3808p AD=0.2128p PS=2.92u PD=1.5u
M$2912 \$877 A1|Y|_062_ VDD|vdd VDD|vdd sg13_lv_pmos L=0.13u W=1.12u AS=0.2128p
+ AD=0.2128p PS=1.5u PD=1.5u
M$2913 VDD|vdd A1|A2|Y|_042_ \$877 VDD|vdd sg13_lv_pmos L=0.13u W=1.12u
+ AS=0.2128p AD=0.3808p PS=1.5u PD=2.92u
M$2914 VDD|vdd D|Y|_006_ \$716 VDD|vdd sg13_lv_pmos L=0.13u W=0.42u AS=0.1428p
+ AD=0.0798p PS=1.52u PD=0.8u
M$2915 VDD|vdd L_HI|RESET_B|net49 \$716 VDD|vdd sg13_lv_pmos L=0.13u W=0.42u
+ AS=0.3623875p AD=0.0798p PS=2.605u PD=0.8u
M$2916 VDD|vdd \$718 \$717 VDD|vdd sg13_lv_pmos L=0.13u W=1u AS=0.3623875p
+ AD=0.34p PS=2.605u PD=2.68u
M$2917 VDD|vdd L_HI|RESET_B|net49 \$718 VDD|vdd sg13_lv_pmos L=0.13u W=0.42u
+ AS=0.1563p AD=0.147p PS=1.22u PD=1.54u
M$2918 VDD|vdd \$717 \$726 VDD|vdd sg13_lv_pmos L=0.13u W=0.42u AS=0.1563p
+ AD=0.063p PS=1.22u PD=0.72u
M$2919 \$726 \$744 \$718 VDD|vdd sg13_lv_pmos L=0.13u W=0.42u AS=0.063p
+ AD=0.0798p PS=0.72u PD=0.8u
M$2920 \$718 \$719 \$716 VDD|vdd sg13_lv_pmos L=0.13u W=0.42u AS=0.0798p
+ AD=0.1428p PS=0.8u PD=1.52u
M$2921 VDD|vdd D|Y|_014_ \$797 VDD|vdd sg13_lv_pmos L=0.13u W=0.42u AS=0.1428p
+ AD=0.0798p PS=1.52u PD=0.8u
M$2922 VDD|vdd L_HI|RESET_B|net58 \$797 VDD|vdd sg13_lv_pmos L=0.13u W=0.42u
+ AS=0.3623875p AD=0.0798p PS=2.605u PD=0.8u
M$2923 VDD|vdd \$867 \$798 VDD|vdd sg13_lv_pmos L=0.13u W=1u AS=0.3623875p
+ AD=0.34p PS=2.605u PD=2.68u
M$2924 VDD|vdd \$744 \$719 VDD|vdd sg13_lv_pmos L=0.13u W=1.12u AS=0.41165p
+ AD=0.3864p PS=2.12u PD=2.93u
M$2925 VDD|vdd A|CLK|X|clknet_2_3__leaf_clk \$744 VDD|vdd sg13_lv_pmos L=0.13u
+ W=1.12u AS=0.41165p AD=0.4088p PS=2.12u PD=2.97u
M$2926 \$717 \$744 \$720 VDD|vdd sg13_lv_pmos L=0.13u W=1u AS=0.34p AD=0.2048p
+ PS=2.68u PD=1.63u
M$2927 \$720 \$719 \$746 VDD|vdd sg13_lv_pmos L=0.13u W=0.42u AS=0.2048p
+ AD=0.09345p PS=1.63u PD=0.865u
M$2928 VDD|vdd \$721 \$746 VDD|vdd sg13_lv_pmos L=0.13u W=0.42u AS=0.204p
+ AD=0.09345p PS=1.835u PD=0.865u
M$2929 VDD|vdd L_HI|RESET_B|net49 \$721 VDD|vdd sg13_lv_pmos L=0.13u W=0.42u
+ AS=0.204p AD=0.0798p PS=1.835u PD=0.8u
M$2930 VDD|vdd \$720 \$721 VDD|vdd sg13_lv_pmos L=0.13u W=0.42u AS=0.4659p
+ AD=0.0798p PS=3.65u PD=0.8u
M$2931 \$878 \$799 VDD|vdd VDD|vdd sg13_lv_pmos L=0.13u W=1.12u AS=0.3864p
+ AD=0.41165p PS=2.93u PD=2.12u
M$2932 VDD|vdd A|CLK|X|clknet_2_3__leaf_clk \$799 VDD|vdd sg13_lv_pmos L=0.13u
+ W=1.12u AS=0.41165p AD=0.4088p PS=2.12u PD=2.97u
M$2933 \$827 \$878 \$879 VDD|vdd sg13_lv_pmos L=0.13u W=0.42u AS=0.2048p
+ AD=0.09345p PS=1.63u PD=0.865u
M$2934 \$879 \$801 VDD|vdd VDD|vdd sg13_lv_pmos L=0.13u W=0.42u AS=0.09345p
+ AD=0.204p PS=0.865u PD=1.835u
M$2935 VDD|vdd L_HI|RESET_B|net58 \$801 VDD|vdd sg13_lv_pmos L=0.13u W=0.42u
+ AS=0.204p AD=0.0798p PS=1.835u PD=0.8u
M$2936 \$801 \$827 VDD|vdd VDD|vdd sg13_lv_pmos L=0.13u W=0.42u AS=0.0798p
+ AD=0.4659p PS=0.8u PD=3.65u
M$2937 \$798 \$799 \$827 VDD|vdd sg13_lv_pmos L=0.13u W=1u AS=0.34p AD=0.2048p
+ PS=2.68u PD=1.63u
M$2938 \$802 \$827 VDD|vdd VDD|vdd sg13_lv_pmos L=0.13u W=1.12u AS=0.3864p
+ AD=0.2128p PS=2.93u PD=1.5u
M$2939 VDD|vdd \$802 A|Q|net26 VDD|vdd sg13_lv_pmos L=0.13u W=1.12u AS=0.2128p
+ AD=0.3808p PS=1.5u PD=2.92u
M$2961 \$849 L_HI|RESET_B|net47 VDD|vdd VDD|vdd sg13_lv_pmos L=0.13u W=0.42u
+ AS=0.147p AD=0.1563p PS=1.54u PD=1.22u
M$2962 VDD|vdd \$771 \$887 VDD|vdd sg13_lv_pmos L=0.13u W=0.42u AS=0.1563p
+ AD=0.063p PS=1.22u PD=0.72u
M$2963 \$887 \$772 \$849 VDD|vdd sg13_lv_pmos L=0.13u W=0.42u AS=0.063p
+ AD=0.0798p PS=0.72u PD=0.8u
M$2964 \$849 \$869 \$770 VDD|vdd sg13_lv_pmos L=0.13u W=0.42u AS=0.0798p
+ AD=0.1428p PS=0.8u PD=1.52u
M$2965 \$912 \$910 VDD|vdd VDD|vdd sg13_lv_pmos L=0.13u W=1.12u AS=0.3864p
+ AD=0.2128p PS=2.93u PD=1.5u
M$2966 VDD|vdd \$912 A|Q|net20 VDD|vdd sg13_lv_pmos L=0.13u W=1.12u AS=0.2128p
+ AD=0.3808p PS=1.5u PD=2.92u
M$2967 A|X|net66 \$914 VDD|vdd VDD|vdd sg13_lv_pmos L=0.13u W=1.12u AS=0.4256p
+ AD=0.2254p PS=3u PD=1.53u
M$2968 VDD|vdd \$915 \$914 VDD|vdd sg13_lv_pmos L=0.5u W=1u AS=0.2254p AD=0.34p
+ PS=1.53u PD=2.68u
M$2969 VDD|vdd A|Q|net19 \$916 VDD|vdd sg13_lv_pmos L=0.13u W=0.42u AS=0.1523p
+ AD=0.1428p PS=1.38u PD=1.52u
M$2970 \$915 \$916 VDD|vdd VDD|vdd sg13_lv_pmos L=0.5u W=1u AS=0.34p AD=0.1523p
+ PS=2.68u PD=1.38u
M$2971 \$854 L_HI|RESET_B|net43 VDD|vdd VDD|vdd sg13_lv_pmos L=0.13u W=0.42u
+ AS=0.147p AD=0.1563p PS=1.54u PD=1.22u
M$2972 VDD|vdd \$778 \$890 VDD|vdd sg13_lv_pmos L=0.13u W=0.42u AS=0.1563p
+ AD=0.063p PS=1.22u PD=0.72u
M$2973 \$890 \$779 \$854 VDD|vdd sg13_lv_pmos L=0.13u W=0.42u AS=0.063p
+ AD=0.0798p PS=0.72u PD=0.8u
M$2974 \$854 \$870 \$777 VDD|vdd sg13_lv_pmos L=0.13u W=0.42u AS=0.0798p
+ AD=0.1428p PS=0.8u PD=1.52u
M$2975 D|Y|_009_ A|B1|X|net29 \$917 VDD|vdd sg13_lv_pmos L=0.13u W=1.12u
+ AS=0.3808p AD=0.2128p PS=2.92u PD=1.5u
M$2976 \$917 A1|Y|_065_ VDD|vdd VDD|vdd sg13_lv_pmos L=0.13u W=1.12u AS=0.2128p
+ AD=0.2128p PS=1.5u PD=1.5u
M$2977 VDD|vdd A1|A2|B_N|Y|_028_ \$917 VDD|vdd sg13_lv_pmos L=0.13u W=1.12u
+ AS=0.2128p AD=0.3808p PS=1.5u PD=2.92u
M$2979 A1|Y|_065_ A|X|net62 VDD|vdd VDD|vdd sg13_lv_pmos L=0.13u W=1.12u
+ AS=0.3808p AD=0.3808p PS=2.92u PD=2.92u
M$2980 A|Q|net10 \$919 VDD|vdd VDD|vdd sg13_lv_pmos L=0.13u W=1.12u AS=0.3808p
+ AD=0.2128p PS=2.92u PD=1.5u
M$2981 VDD|vdd \$978 \$919 VDD|vdd sg13_lv_pmos L=0.13u W=1.12u AS=0.2128p
+ AD=0.3864p PS=1.5u PD=2.93u
M$2984 \$930 \$928 VDD|vdd VDD|vdd sg13_lv_pmos L=0.13u W=1.12u AS=0.3864p
+ AD=0.2128p PS=2.93u PD=1.5u
M$2985 VDD|vdd \$930 A|Q|net22 VDD|vdd sg13_lv_pmos L=0.13u W=1.12u AS=0.2128p
+ AD=0.3808p PS=1.5u PD=2.92u
M$2986 A|X|net63 \$932 VDD|vdd VDD|vdd sg13_lv_pmos L=0.13u W=1.12u AS=0.4256p
+ AD=0.2254p PS=3u PD=1.53u
M$2987 VDD|vdd \$933 \$932 VDD|vdd sg13_lv_pmos L=0.5u W=1u AS=0.2254p AD=0.34p
+ PS=1.53u PD=2.68u
M$2988 VDD|vdd A|Q|net22 \$934 VDD|vdd sg13_lv_pmos L=0.13u W=0.42u AS=0.1523p
+ AD=0.1428p PS=1.38u PD=1.52u
M$2989 \$933 \$934 VDD|vdd VDD|vdd sg13_lv_pmos L=0.5u W=1u AS=0.34p AD=0.1523p
+ PS=2.68u PD=1.38u
M$2990 \$859 L_HI|RESET_B|net52 VDD|vdd VDD|vdd sg13_lv_pmos L=0.13u W=0.42u
+ AS=0.147p AD=0.1563p PS=1.54u PD=1.22u
M$2991 VDD|vdd \$785 \$897 VDD|vdd sg13_lv_pmos L=0.13u W=0.42u AS=0.1563p
+ AD=0.063p PS=1.22u PD=0.72u
M$2992 \$897 \$786 \$859 VDD|vdd sg13_lv_pmos L=0.13u W=0.42u AS=0.063p
+ AD=0.0798p PS=0.72u PD=0.8u
M$2993 \$859 \$873 \$784 VDD|vdd sg13_lv_pmos L=0.13u W=0.42u AS=0.0798p
+ AD=0.1428p PS=0.8u PD=1.52u
M$2994 D|Y|_021_ A|B1|X|net30 \$935 VDD|vdd sg13_lv_pmos L=0.13u W=1.12u
+ AS=0.3808p AD=0.2128p PS=2.92u PD=1.5u
M$2995 \$935 A1|Y|_056_ VDD|vdd VDD|vdd sg13_lv_pmos L=0.13u W=1.12u AS=0.2128p
+ AD=0.2128p PS=1.5u PD=1.5u
M$2996 VDD|vdd A2|Y|_057_ \$935 VDD|vdd sg13_lv_pmos L=0.13u W=1.12u AS=0.2128p
+ AD=0.3808p PS=1.5u PD=2.92u
M$2997 \$942 \$940 VDD|vdd VDD|vdd sg13_lv_pmos L=0.13u W=1.12u AS=0.3864p
+ AD=0.2128p PS=2.93u PD=1.5u
M$2998 VDD|vdd \$942 A|Q|net23 VDD|vdd sg13_lv_pmos L=0.13u W=1.12u AS=0.2128p
+ AD=0.3808p PS=1.5u PD=2.92u
M$3000 \$863 L_HI|RESET_B|net51 VDD|vdd VDD|vdd sg13_lv_pmos L=0.13u W=0.42u
+ AS=0.147p AD=0.1563p PS=1.54u PD=1.22u
M$3001 VDD|vdd \$791 \$896 VDD|vdd sg13_lv_pmos L=0.13u W=0.42u AS=0.1563p
+ AD=0.063p PS=1.22u PD=0.72u
M$3002 \$896 \$792 \$863 VDD|vdd sg13_lv_pmos L=0.13u W=0.42u AS=0.063p
+ AD=0.0798p PS=0.72u PD=0.8u
M$3003 \$863 \$876 \$790 VDD|vdd sg13_lv_pmos L=0.13u W=0.42u AS=0.0798p
+ AD=0.1428p PS=0.8u PD=1.52u
M$3004 \$950 \$948 VDD|vdd VDD|vdd sg13_lv_pmos L=0.13u W=1.12u AS=0.3864p
+ AD=0.2128p PS=2.93u PD=1.5u
M$3005 VDD|vdd \$950 A|Q|net24 VDD|vdd sg13_lv_pmos L=0.13u W=1.12u AS=0.2128p
+ AD=0.3808p PS=1.5u PD=2.92u
M$3006 A|X|net72 \$952 VDD|vdd VDD|vdd sg13_lv_pmos L=0.13u W=1.12u AS=0.4256p
+ AD=0.2254p PS=3u PD=1.53u
M$3007 VDD|vdd \$953 \$952 VDD|vdd sg13_lv_pmos L=0.5u W=1u AS=0.2254p AD=0.34p
+ PS=1.53u PD=2.68u
M$3008 VDD|vdd A|Q|net17 \$954 VDD|vdd sg13_lv_pmos L=0.13u W=0.42u AS=0.1523p
+ AD=0.1428p PS=1.38u PD=1.52u
M$3009 \$953 \$954 VDD|vdd VDD|vdd sg13_lv_pmos L=0.5u W=1u AS=0.34p AD=0.1523p
+ PS=2.68u PD=1.38u
M$3013 \$867 L_HI|RESET_B|net58 VDD|vdd VDD|vdd sg13_lv_pmos L=0.13u W=0.42u
+ AS=0.147p AD=0.1563p PS=1.54u PD=1.22u
M$3014 VDD|vdd \$798 \$888 VDD|vdd sg13_lv_pmos L=0.13u W=0.42u AS=0.1563p
+ AD=0.063p PS=1.22u PD=0.72u
M$3015 \$888 \$799 \$867 VDD|vdd sg13_lv_pmos L=0.13u W=0.42u AS=0.063p
+ AD=0.0798p PS=0.72u PD=0.8u
M$3016 \$867 \$878 \$797 VDD|vdd sg13_lv_pmos L=0.13u W=0.42u AS=0.0798p
+ AD=0.1428p PS=0.8u PD=1.52u
M$3017 \$961 \$959 VDD|vdd VDD|vdd sg13_lv_pmos L=0.13u W=1.12u AS=0.3864p
+ AD=0.2128p PS=2.93u PD=1.5u
M$3018 VDD|vdd \$961 A|Q|net25 VDD|vdd sg13_lv_pmos L=0.13u W=1.12u AS=0.2128p
+ AD=0.3808p PS=1.5u PD=2.92u
M$3019 B_N|X|net59 \$964 VDD|vdd VDD|vdd sg13_lv_pmos L=0.13u W=1.12u
+ AS=0.4256p AD=0.2254p PS=3u PD=1.53u
M$3020 VDD|vdd \$965 \$964 VDD|vdd sg13_lv_pmos L=0.5u W=1u AS=0.2254p AD=0.34p
+ PS=1.53u PD=2.68u
M$3021 VDD|vdd A|Q|net26 \$966 VDD|vdd sg13_lv_pmos L=0.13u W=0.42u AS=0.1523p
+ AD=0.1428p PS=1.38u PD=1.52u
M$3022 \$965 \$966 VDD|vdd VDD|vdd sg13_lv_pmos L=0.5u W=1u AS=0.34p AD=0.1523p
+ PS=2.68u PD=1.38u
M$3044 VDD|vdd D|Y|_008_ \$906 VDD|vdd sg13_lv_pmos L=0.13u W=0.42u AS=0.1428p
+ AD=0.0798p PS=1.52u PD=0.8u
M$3045 VDD|vdd L_HI|RESET_B|net45 \$906 VDD|vdd sg13_lv_pmos L=0.13u W=0.42u
+ AS=0.3623875p AD=0.0798p PS=2.605u PD=0.8u
M$3046 VDD|vdd \$908 \$907 VDD|vdd sg13_lv_pmos L=0.13u W=1u AS=0.3623875p
+ AD=0.34p PS=2.605u PD=2.68u
M$3047 VDD|vdd L_HI|RESET_B|net45 \$908 VDD|vdd sg13_lv_pmos L=0.13u W=0.42u
+ AS=0.1563p AD=0.147p PS=1.22u PD=1.54u
M$3048 VDD|vdd \$907 \$968 VDD|vdd sg13_lv_pmos L=0.13u W=0.42u AS=0.1563p
+ AD=0.063p PS=1.22u PD=0.72u
M$3049 \$968 \$975 \$908 VDD|vdd sg13_lv_pmos L=0.13u W=0.42u AS=0.063p
+ AD=0.0798p PS=0.72u PD=0.8u
M$3050 \$908 \$909 \$906 VDD|vdd sg13_lv_pmos L=0.13u W=0.42u AS=0.0798p
+ AD=0.1428p PS=0.8u PD=1.52u
M$3051 VDD|vdd \$975 \$909 VDD|vdd sg13_lv_pmos L=0.13u W=1.12u AS=0.41165p
+ AD=0.3864p PS=2.12u PD=2.93u
M$3052 VDD|vdd A|CLK|X|clknet_2_1__leaf_clk \$975 VDD|vdd sg13_lv_pmos L=0.13u
+ W=1.12u AS=0.41165p AD=0.4088p PS=2.12u PD=2.97u
M$3053 \$907 \$975 \$910 VDD|vdd sg13_lv_pmos L=0.13u W=1u AS=0.34p AD=0.2048p
+ PS=2.68u PD=1.63u
M$3054 \$910 \$909 \$991 VDD|vdd sg13_lv_pmos L=0.13u W=0.42u AS=0.2048p
+ AD=0.09345p PS=1.63u PD=0.865u
M$3055 VDD|vdd \$911 \$991 VDD|vdd sg13_lv_pmos L=0.13u W=0.42u AS=0.204p
+ AD=0.09345p PS=1.835u PD=0.865u
M$3056 VDD|vdd L_HI|RESET_B|net45 \$911 VDD|vdd sg13_lv_pmos L=0.13u W=0.42u
+ AS=0.204p AD=0.0798p PS=1.835u PD=0.8u
M$3057 VDD|vdd \$910 \$911 VDD|vdd sg13_lv_pmos L=0.13u W=0.42u AS=0.4659p
+ AD=0.0798p PS=3.65u PD=0.8u
M$3058 VDD|vdd \$978 \$920 VDD|vdd sg13_lv_pmos L=0.13u W=0.42u AS=0.4659p
+ AD=0.0798p PS=3.65u PD=0.8u
M$3059 VDD|vdd L_HI|RESET_B|net34 \$920 VDD|vdd sg13_lv_pmos L=0.13u W=0.42u
+ AS=0.204p AD=0.0798p PS=1.835u PD=0.8u
M$3060 VDD|vdd \$920 \$992 VDD|vdd sg13_lv_pmos L=0.13u W=0.42u AS=0.204p
+ AD=0.09345p PS=1.835u PD=0.865u
M$3061 \$978 \$921 \$992 VDD|vdd sg13_lv_pmos L=0.13u W=0.42u AS=0.2048p
+ AD=0.09345p PS=1.63u PD=0.865u
M$3062 \$978 \$979 \$981 VDD|vdd sg13_lv_pmos L=0.13u W=1u AS=0.2048p AD=0.34p
+ PS=1.63u PD=2.68u
M$3063 VDD|vdd A|CLK|X|clknet_2_1__leaf_clk \$979 VDD|vdd sg13_lv_pmos L=0.13u
+ W=1.12u AS=0.41165p AD=0.4088p PS=2.12u PD=2.97u
M$3064 VDD|vdd \$979 \$921 VDD|vdd sg13_lv_pmos L=0.13u W=1.12u AS=0.41165p
+ AD=0.3864p PS=2.12u PD=2.93u
M$3065 \$922 \$921 \$923 VDD|vdd sg13_lv_pmos L=0.13u W=0.42u AS=0.1428p
+ AD=0.0798p PS=1.52u PD=0.8u
M$3066 \$923 \$979 \$972 VDD|vdd sg13_lv_pmos L=0.13u W=0.42u AS=0.0798p
+ AD=0.063p PS=0.8u PD=0.72u
M$3067 VDD|vdd \$981 \$972 VDD|vdd sg13_lv_pmos L=0.13u W=0.42u AS=0.1563p
+ AD=0.063p PS=1.22u PD=0.72u
M$3068 VDD|vdd L_HI|RESET_B|net34 \$923 VDD|vdd sg13_lv_pmos L=0.13u W=0.42u
+ AS=0.1563p AD=0.147p PS=1.22u PD=1.54u
M$3069 VDD|vdd \$923 \$981 VDD|vdd sg13_lv_pmos L=0.13u W=1u AS=0.3623875p
+ AD=0.34p PS=2.605u PD=2.68u
M$3070 VDD|vdd L_HI|RESET_B|net34 \$922 VDD|vdd sg13_lv_pmos L=0.13u W=0.42u
+ AS=0.3623875p AD=0.0798p PS=2.605u PD=0.8u
M$3071 \$922 D|Y|_020_ VDD|vdd VDD|vdd sg13_lv_pmos L=0.13u W=0.42u AS=0.0798p
+ AD=0.1428p PS=0.8u PD=1.52u
M$3072 VDD|vdd D|Y|_010_ \$924 VDD|vdd sg13_lv_pmos L=0.13u W=0.42u AS=0.1428p
+ AD=0.0798p PS=1.52u PD=0.8u
M$3073 VDD|vdd L_HI|RESET_B|net41 \$924 VDD|vdd sg13_lv_pmos L=0.13u W=0.42u
+ AS=0.3623875p AD=0.0798p PS=2.605u PD=0.8u
M$3074 VDD|vdd \$926 \$925 VDD|vdd sg13_lv_pmos L=0.13u W=1u AS=0.3623875p
+ AD=0.34p PS=2.605u PD=2.68u
M$3075 VDD|vdd L_HI|RESET_B|net41 \$926 VDD|vdd sg13_lv_pmos L=0.13u W=0.42u
+ AS=0.1563p AD=0.147p PS=1.22u PD=1.54u
M$3076 VDD|vdd \$925 \$971 VDD|vdd sg13_lv_pmos L=0.13u W=0.42u AS=0.1563p
+ AD=0.063p PS=1.22u PD=0.72u
M$3077 \$971 \$983 \$926 VDD|vdd sg13_lv_pmos L=0.13u W=0.42u AS=0.063p
+ AD=0.0798p PS=0.72u PD=0.8u
M$3078 \$926 \$927 \$924 VDD|vdd sg13_lv_pmos L=0.13u W=0.42u AS=0.0798p
+ AD=0.1428p PS=0.8u PD=1.52u
M$3079 VDD|vdd \$983 \$927 VDD|vdd sg13_lv_pmos L=0.13u W=1.12u AS=0.41165p
+ AD=0.3864p PS=2.12u PD=2.93u
M$3080 VDD|vdd A|CLK|X|clknet_2_1__leaf_clk \$983 VDD|vdd sg13_lv_pmos L=0.13u
+ W=1.12u AS=0.41165p AD=0.4088p PS=2.12u PD=2.97u
M$3081 \$925 \$983 \$928 VDD|vdd sg13_lv_pmos L=0.13u W=1u AS=0.34p AD=0.2048p
+ PS=2.68u PD=1.63u
M$3082 \$928 \$927 \$994 VDD|vdd sg13_lv_pmos L=0.13u W=0.42u AS=0.2048p
+ AD=0.09345p PS=1.63u PD=0.865u
M$3083 VDD|vdd \$929 \$994 VDD|vdd sg13_lv_pmos L=0.13u W=0.42u AS=0.204p
+ AD=0.09345p PS=1.835u PD=0.865u
M$3084 VDD|vdd L_HI|RESET_B|net41 \$929 VDD|vdd sg13_lv_pmos L=0.13u W=0.42u
+ AS=0.204p AD=0.0798p PS=1.835u PD=0.8u
M$3085 VDD|vdd \$928 \$929 VDD|vdd sg13_lv_pmos L=0.13u W=0.42u AS=0.4659p
+ AD=0.0798p PS=3.65u PD=0.8u
M$3086 VDD|vdd D|Y|_011_ \$936 VDD|vdd sg13_lv_pmos L=0.13u W=0.42u AS=0.1428p
+ AD=0.0798p PS=1.52u PD=0.8u
M$3087 VDD|vdd L_HI|RESET_B|net39 \$936 VDD|vdd sg13_lv_pmos L=0.13u W=0.42u
+ AS=0.3623875p AD=0.0798p PS=2.605u PD=0.8u
M$3088 VDD|vdd \$938 \$937 VDD|vdd sg13_lv_pmos L=0.13u W=1u AS=0.3623875p
+ AD=0.34p PS=2.605u PD=2.68u
M$3089 VDD|vdd L_HI|RESET_B|net39 \$938 VDD|vdd sg13_lv_pmos L=0.13u W=0.42u
+ AS=0.1563p AD=0.147p PS=1.22u PD=1.54u
M$3090 VDD|vdd \$937 \$970 VDD|vdd sg13_lv_pmos L=0.13u W=0.42u AS=0.1563p
+ AD=0.063p PS=1.22u PD=0.72u
M$3091 \$970 \$985 \$938 VDD|vdd sg13_lv_pmos L=0.13u W=0.42u AS=0.063p
+ AD=0.0798p PS=0.72u PD=0.8u
M$3092 \$938 \$939 \$936 VDD|vdd sg13_lv_pmos L=0.13u W=0.42u AS=0.0798p
+ AD=0.1428p PS=0.8u PD=1.52u
M$3093 VDD|vdd \$985 \$939 VDD|vdd sg13_lv_pmos L=0.13u W=1.12u AS=0.41165p
+ AD=0.3864p PS=2.12u PD=2.93u
M$3094 VDD|vdd A|CLK|X|clknet_2_3__leaf_clk \$985 VDD|vdd sg13_lv_pmos L=0.13u
+ W=1.12u AS=0.41165p AD=0.4088p PS=2.12u PD=2.97u
M$3095 \$937 \$985 \$940 VDD|vdd sg13_lv_pmos L=0.13u W=1u AS=0.34p AD=0.2048p
+ PS=2.68u PD=1.63u
M$3096 \$940 \$939 \$995 VDD|vdd sg13_lv_pmos L=0.13u W=0.42u AS=0.2048p
+ AD=0.09345p PS=1.63u PD=0.865u
M$3097 VDD|vdd \$941 \$995 VDD|vdd sg13_lv_pmos L=0.13u W=0.42u AS=0.204p
+ AD=0.09345p PS=1.835u PD=0.865u
M$3098 VDD|vdd L_HI|RESET_B|net39 \$941 VDD|vdd sg13_lv_pmos L=0.13u W=0.42u
+ AS=0.204p AD=0.0798p PS=1.835u PD=0.8u
M$3099 VDD|vdd \$940 \$941 VDD|vdd sg13_lv_pmos L=0.13u W=0.42u AS=0.4659p
+ AD=0.0798p PS=3.65u PD=0.8u
M$3100 VDD|vdd D|Y|_012_ \$944 VDD|vdd sg13_lv_pmos L=0.13u W=0.42u AS=0.1428p
+ AD=0.0798p PS=1.52u PD=0.8u
M$3101 VDD|vdd L_HI|RESET_B|net37 \$944 VDD|vdd sg13_lv_pmos L=0.13u W=0.42u
+ AS=0.3623875p AD=0.0798p PS=2.605u PD=0.8u
M$3102 VDD|vdd \$946 \$945 VDD|vdd sg13_lv_pmos L=0.13u W=1u AS=0.3623875p
+ AD=0.34p PS=2.605u PD=2.68u
M$3103 VDD|vdd L_HI|RESET_B|net37 \$946 VDD|vdd sg13_lv_pmos L=0.13u W=0.42u
+ AS=0.1563p AD=0.147p PS=1.22u PD=1.54u
M$3104 VDD|vdd \$945 \$969 VDD|vdd sg13_lv_pmos L=0.13u W=0.42u AS=0.1563p
+ AD=0.063p PS=1.22u PD=0.72u
M$3105 \$969 \$988 \$946 VDD|vdd sg13_lv_pmos L=0.13u W=0.42u AS=0.063p
+ AD=0.0798p PS=0.72u PD=0.8u
M$3106 \$946 \$947 \$944 VDD|vdd sg13_lv_pmos L=0.13u W=0.42u AS=0.0798p
+ AD=0.1428p PS=0.8u PD=1.52u
M$3107 VDD|vdd \$988 \$947 VDD|vdd sg13_lv_pmos L=0.13u W=1.12u AS=0.41165p
+ AD=0.3864p PS=2.12u PD=2.93u
M$3108 VDD|vdd A|CLK|X|clknet_2_3__leaf_clk \$988 VDD|vdd sg13_lv_pmos L=0.13u
+ W=1.12u AS=0.41165p AD=0.4088p PS=2.12u PD=2.97u
M$3109 \$945 \$988 \$948 VDD|vdd sg13_lv_pmos L=0.13u W=1u AS=0.34p AD=0.2048p
+ PS=2.68u PD=1.63u
M$3110 \$948 \$947 \$996 VDD|vdd sg13_lv_pmos L=0.13u W=0.42u AS=0.2048p
+ AD=0.09345p PS=1.63u PD=0.865u
M$3111 VDD|vdd \$949 \$996 VDD|vdd sg13_lv_pmos L=0.13u W=0.42u AS=0.204p
+ AD=0.09345p PS=1.835u PD=0.865u
M$3112 VDD|vdd L_HI|RESET_B|net37 \$949 VDD|vdd sg13_lv_pmos L=0.13u W=0.42u
+ AS=0.204p AD=0.0798p PS=1.835u PD=0.8u
M$3113 VDD|vdd \$948 \$949 VDD|vdd sg13_lv_pmos L=0.13u W=0.42u AS=0.4659p
+ AD=0.0798p PS=3.65u PD=0.8u
M$3114 VDD|vdd D|Y|_013_ \$955 VDD|vdd sg13_lv_pmos L=0.13u W=0.42u AS=0.1428p
+ AD=0.0798p PS=1.52u PD=0.8u
M$3115 VDD|vdd L_HI|RESET_B|net35 \$955 VDD|vdd sg13_lv_pmos L=0.13u W=0.42u
+ AS=0.3623875p AD=0.0798p PS=2.605u PD=0.8u
M$3116 VDD|vdd \$957 \$956 VDD|vdd sg13_lv_pmos L=0.13u W=1u AS=0.3623875p
+ AD=0.34p PS=2.605u PD=2.68u
M$3117 VDD|vdd L_HI|RESET_B|net35 \$957 VDD|vdd sg13_lv_pmos L=0.13u W=0.42u
+ AS=0.1563p AD=0.147p PS=1.22u PD=1.54u
M$3118 VDD|vdd \$956 \$967 VDD|vdd sg13_lv_pmos L=0.13u W=0.42u AS=0.1563p
+ AD=0.063p PS=1.22u PD=0.72u
M$3119 \$967 \$990 \$957 VDD|vdd sg13_lv_pmos L=0.13u W=0.42u AS=0.063p
+ AD=0.0798p PS=0.72u PD=0.8u
M$3120 \$957 \$958 \$955 VDD|vdd sg13_lv_pmos L=0.13u W=0.42u AS=0.0798p
+ AD=0.1428p PS=0.8u PD=1.52u
M$3121 VDD|vdd \$990 \$958 VDD|vdd sg13_lv_pmos L=0.13u W=1.12u AS=0.41165p
+ AD=0.3864p PS=2.12u PD=2.93u
M$3122 VDD|vdd A|CLK|X|clknet_2_3__leaf_clk \$990 VDD|vdd sg13_lv_pmos L=0.13u
+ W=1.12u AS=0.41165p AD=0.4088p PS=2.12u PD=2.97u
M$3123 \$956 \$990 \$959 VDD|vdd sg13_lv_pmos L=0.13u W=1u AS=0.34p AD=0.2048p
+ PS=2.68u PD=1.63u
M$3124 \$959 \$958 \$993 VDD|vdd sg13_lv_pmos L=0.13u W=0.42u AS=0.2048p
+ AD=0.09345p PS=1.63u PD=0.865u
M$3125 VDD|vdd \$960 \$993 VDD|vdd sg13_lv_pmos L=0.13u W=0.42u AS=0.204p
+ AD=0.09345p PS=1.835u PD=0.865u
M$3126 VDD|vdd L_HI|RESET_B|net35 \$960 VDD|vdd sg13_lv_pmos L=0.13u W=0.42u
+ AS=0.204p AD=0.0798p PS=1.835u PD=0.8u
M$3127 VDD|vdd \$959 \$960 VDD|vdd sg13_lv_pmos L=0.13u W=0.42u AS=0.4659p
+ AD=0.0798p PS=3.65u PD=0.8u
M$3128 BN[5]|X \$1069 VDD|vdd VDD|vdd sg13_lv_pmos L=0.13u W=1.12u AS=0.42p
+ AD=0.2114p PS=2.99u PD=1.54u
M$3129 VDD|vdd A|Q|net10 \$1069 VDD|vdd sg13_lv_pmos L=0.13u W=0.84u AS=0.2114p
+ AD=0.2856p PS=1.54u PD=2.36u
M$3130 BN[6]|X \$1070 VDD|vdd VDD|vdd sg13_lv_pmos L=0.13u W=1.12u AS=0.42p
+ AD=0.2114p PS=2.99u PD=1.54u
M$3131 VDD|vdd A|Q|net11 \$1070 VDD|vdd sg13_lv_pmos L=0.13u W=0.84u AS=0.2114p
+ AD=0.2856p PS=1.54u PD=2.36u
M$3134 D[0]|X \$1071 VDD|vdd VDD|vdd sg13_lv_pmos L=0.13u W=1.12u AS=0.42p
+ AD=0.2114p PS=2.99u PD=1.54u
M$3135 VDD|vdd A|Q|net19 \$1071 VDD|vdd sg13_lv_pmos L=0.13u W=0.84u AS=0.2114p
+ AD=0.2856p PS=1.54u PD=2.36u
M$3143 VDD|vdd \$1033 \$1072 VDD|vdd sg13_lv_pmos L=0.13u W=0.66u AS=0.4657125p
+ AD=0.2442p PS=2.54u PD=2.06u
M$3144 L_HI|RESET_B|net45 \$1032 VDD|vdd VDD|vdd sg13_lv_pmos L=0.13u W=1.155u
+ AS=0.3927p AD=0.4657125p PS=2.99u PD=2.54u
M$3146 D[1]|X \$1073 VDD|vdd VDD|vdd sg13_lv_pmos L=0.13u W=1.12u AS=0.42p
+ AD=0.2114p PS=2.99u PD=1.54u
M$3147 VDD|vdd A|Q|net20 \$1073 VDD|vdd sg13_lv_pmos L=0.13u W=0.84u AS=0.2114p
+ AD=0.2856p PS=1.54u PD=2.36u
M$3148 D|Y|_008_ A|B1|X|net29 \$1100 VDD|vdd sg13_lv_pmos L=0.13u W=1.12u
+ AS=0.3808p AD=0.2128p PS=2.92u PD=1.5u
M$3149 \$1100 A1|Y|_066_ VDD|vdd VDD|vdd sg13_lv_pmos L=0.13u W=1.12u
+ AS=0.2128p AD=0.2128p PS=1.5u PD=1.5u
M$3150 VDD|vdd A1|A2|Y|_099_ \$1100 VDD|vdd sg13_lv_pmos L=0.13u W=1.12u
+ AS=0.2128p AD=0.3808p PS=1.5u PD=2.92u
M$3152 VDD|vdd A|Q|net20 \$1035 VDD|vdd sg13_lv_pmos L=0.13u W=0.42u AS=0.1523p
+ AD=0.1428p PS=1.38u PD=1.52u
M$3153 VDD|vdd \$1035 \$1036 VDD|vdd sg13_lv_pmos L=0.5u W=1u AS=0.1523p
+ AD=0.34p PS=1.38u PD=2.68u
M$3154 \$1037 \$1036 VDD|vdd VDD|vdd sg13_lv_pmos L=0.5u W=1u AS=0.34p
+ AD=0.2254p PS=2.68u PD=1.53u
M$3155 VDD|vdd \$1037 A|X|net65 VDD|vdd sg13_lv_pmos L=0.13u W=1.12u AS=0.2254p
+ AD=0.4256p PS=1.53u PD=3u
M$3156 VDD|vdd \$1039 \$1074 VDD|vdd sg13_lv_pmos L=0.13u W=0.66u AS=0.4657125p
+ AD=0.2442p PS=2.54u PD=2.06u
M$3157 L_HI|RESET_B|net43 \$1038 VDD|vdd VDD|vdd sg13_lv_pmos L=0.13u W=1.155u
+ AS=0.3927p AD=0.4657125p PS=2.99u PD=2.54u
M$3160 VDD|vdd A|Q|net21 \$1075 VDD|vdd sg13_lv_pmos L=0.13u W=0.84u AS=0.2114p
+ AD=0.2856p PS=1.54u PD=2.36u
M$3161 VDD|vdd \$1075 D[2]|X VDD|vdd sg13_lv_pmos L=0.13u W=1.12u AS=0.2114p
+ AD=0.42p PS=1.54u PD=2.99u
M$3162 VDD|vdd \$1077 \$1076 VDD|vdd sg13_lv_pmos L=0.5u W=1u AS=0.2254p
+ AD=0.34p PS=1.53u PD=2.68u
M$3163 A|X|net62 \$1076 VDD|vdd VDD|vdd sg13_lv_pmos L=0.13u W=1.12u AS=0.4256p
+ AD=0.2254p PS=3u PD=1.53u
M$3164 VDD|vdd A|Q|net21 \$1041 VDD|vdd sg13_lv_pmos L=0.13u W=0.42u AS=0.1523p
+ AD=0.1428p PS=1.38u PD=1.52u
M$3165 \$1077 \$1041 VDD|vdd VDD|vdd sg13_lv_pmos L=0.5u W=1u AS=0.34p
+ AD=0.1523p PS=2.68u PD=1.38u
M$3166 \$1078 \$1042 VDD|vdd VDD|vdd sg13_lv_pmos L=0.13u W=0.66u AS=0.2442p
+ AD=0.4657125p PS=2.06u PD=2.54u
M$3167 VDD|vdd \$1043 L_HI|RESET_B|net34 VDD|vdd sg13_lv_pmos L=0.13u W=1.155u
+ AS=0.4657125p AD=0.3927p PS=2.54u PD=2.99u
M$3172 VDD|vdd \$1045 \$1079 VDD|vdd sg13_lv_pmos L=0.13u W=0.66u AS=0.4657125p
+ AD=0.2442p PS=2.54u PD=2.06u
M$3173 L_HI|RESET_B|net41 \$1044 VDD|vdd VDD|vdd sg13_lv_pmos L=0.13u W=1.155u
+ AS=0.3927p AD=0.4657125p PS=2.99u PD=2.54u
M$3176 D[3]|X \$1080 VDD|vdd VDD|vdd sg13_lv_pmos L=0.13u W=1.12u AS=0.42p
+ AD=0.2114p PS=2.99u PD=1.54u
M$3177 VDD|vdd A|Q|net22 \$1080 VDD|vdd sg13_lv_pmos L=0.13u W=0.84u AS=0.2114p
+ AD=0.2856p PS=1.54u PD=2.36u
M$3181 VDD|vdd \$1048 \$1081 VDD|vdd sg13_lv_pmos L=0.13u W=0.66u AS=0.4657125p
+ AD=0.2442p PS=2.54u PD=2.06u
M$3182 L_HI|RESET_B|net52 \$1047 VDD|vdd VDD|vdd sg13_lv_pmos L=0.13u W=1.155u
+ AS=0.3927p AD=0.4657125p PS=2.99u PD=2.54u
M$3186 VDD|vdd \$1050 \$1082 VDD|vdd sg13_lv_pmos L=0.13u W=0.66u AS=0.4657125p
+ AD=0.2442p PS=2.54u PD=2.06u
M$3187 L_HI|RESET_B|net39 \$1049 VDD|vdd VDD|vdd sg13_lv_pmos L=0.13u W=1.155u
+ AS=0.3927p AD=0.4657125p PS=2.99u PD=2.54u
M$3189 D[4]|X \$1083 VDD|vdd VDD|vdd sg13_lv_pmos L=0.13u W=1.12u AS=0.42p
+ AD=0.2114p PS=2.99u PD=1.54u
M$3190 VDD|vdd A|Q|net23 \$1083 VDD|vdd sg13_lv_pmos L=0.13u W=0.84u AS=0.2114p
+ AD=0.2856p PS=1.54u PD=2.36u
M$3195 Y$1 A|CLK|X|clknet_2_3__leaf_clk VDD|vdd VDD|vdd sg13_lv_pmos L=0.13u
+ W=1.12u AS=0.3808p AD=0.3808p PS=2.92u PD=2.92u
M$3196 VDD|vdd \$1054 \$1084 VDD|vdd sg13_lv_pmos L=0.13u W=0.66u AS=0.4657125p
+ AD=0.2442p PS=2.54u PD=2.06u
M$3197 L_HI|RESET_B|net37 \$1053 VDD|vdd VDD|vdd sg13_lv_pmos L=0.13u W=1.155u
+ AS=0.3927p AD=0.4657125p PS=2.99u PD=2.54u
M$3198 A1|Y|_063_ A|X|net64 VDD|vdd VDD|vdd sg13_lv_pmos L=0.13u W=1.12u
+ AS=0.3808p AD=0.3808p PS=2.92u PD=2.92u
M$3199 VDD|vdd \$1056 \$1086 VDD|vdd sg13_lv_pmos L=0.13u W=0.66u AS=0.4657125p
+ AD=0.2442p PS=2.54u PD=2.06u
M$3200 L_HI|RESET_B|net51 \$1055 VDD|vdd VDD|vdd sg13_lv_pmos L=0.13u W=1.155u
+ AS=0.3927p AD=0.4657125p PS=2.99u PD=2.54u
M$3201 VDD|vdd \$1088 \$1087 VDD|vdd sg13_lv_pmos L=0.5u W=1u AS=0.2254p
+ AD=0.34p PS=1.53u PD=2.68u
M$3202 A|X|net64 \$1087 VDD|vdd VDD|vdd sg13_lv_pmos L=0.13u W=1.12u AS=0.4256p
+ AD=0.2254p PS=3u PD=1.53u
M$3203 VDD|vdd A|Q|net24 \$1057 VDD|vdd sg13_lv_pmos L=0.13u W=0.42u AS=0.1523p
+ AD=0.1428p PS=1.38u PD=1.52u
M$3204 \$1088 \$1057 VDD|vdd VDD|vdd sg13_lv_pmos L=0.5u W=1u AS=0.34p
+ AD=0.1523p PS=2.68u PD=1.38u
M$3205 D[5]|X \$1089 VDD|vdd VDD|vdd sg13_lv_pmos L=0.13u W=1.12u AS=0.42p
+ AD=0.2114p PS=2.99u PD=1.54u
M$3206 VDD|vdd A|Q|net24 \$1089 VDD|vdd sg13_lv_pmos L=0.13u W=0.84u AS=0.2114p
+ AD=0.2856p PS=1.54u PD=2.36u
M$3211 VDD|vdd \$1060 \$1090 VDD|vdd sg13_lv_pmos L=0.13u W=0.66u AS=0.4657125p
+ AD=0.2442p PS=2.54u PD=2.06u
M$3212 L_HI|RESET_B|net35 \$1059 VDD|vdd VDD|vdd sg13_lv_pmos L=0.13u W=1.155u
+ AS=0.3927p AD=0.4657125p PS=2.99u PD=2.54u
M$3213 VDD|vdd B_N|X|net59 \$1091 VDD|vdd sg13_lv_pmos L=0.13u W=0.84u
+ AS=0.2618p AD=0.2856p PS=1.63u PD=2.36u
M$3214 D|Y|_014_ A|B1|X|net31 \$1105 VDD|vdd sg13_lv_pmos L=0.13u W=1.12u
+ AS=0.3808p AD=0.1176p PS=2.92u PD=1.33u
M$3215 \$1105 \$1091 VDD|vdd VDD|vdd sg13_lv_pmos L=0.13u W=1.12u AS=0.1176p
+ AD=0.2618p PS=1.33u PD=1.63u
M$3216 A1|Y|_062_ A|X|net61 VDD|vdd VDD|vdd sg13_lv_pmos L=0.13u W=1.12u
+ AS=0.3808p AD=0.3808p PS=2.92u PD=2.92u
M$3217 VDD|vdd \$1062 \$1093 VDD|vdd sg13_lv_pmos L=0.13u W=0.66u AS=0.4657125p
+ AD=0.2442p PS=2.54u PD=2.06u
M$3218 L_HI|RESET_B|net58 \$1061 VDD|vdd VDD|vdd sg13_lv_pmos L=0.13u W=1.155u
+ AS=0.3927p AD=0.4657125p PS=2.99u PD=2.54u
M$3219 VDD|vdd \$1094 \$1063 VDD|vdd sg13_lv_pmos L=0.5u W=1u AS=0.2254p
+ AD=0.34p PS=1.53u PD=2.68u
M$3220 A|X|net61 \$1063 VDD|vdd VDD|vdd sg13_lv_pmos L=0.13u W=1.12u AS=0.4256p
+ AD=0.2254p PS=3u PD=1.53u
M$3221 VDD|vdd A|Q|net25 \$1064 VDD|vdd sg13_lv_pmos L=0.13u W=0.42u AS=0.1523p
+ AD=0.1428p PS=1.38u PD=1.52u
M$3222 \$1094 \$1064 VDD|vdd VDD|vdd sg13_lv_pmos L=0.5u W=1u AS=0.34p
+ AD=0.1523p PS=2.68u PD=1.38u
M$3223 D[6]|X \$1095 VDD|vdd VDD|vdd sg13_lv_pmos L=0.13u W=1.12u AS=0.42p
+ AD=0.2114p PS=2.99u PD=1.54u
M$3224 VDD|vdd A|Q|net25 \$1095 VDD|vdd sg13_lv_pmos L=0.13u W=0.84u AS=0.2114p
+ AD=0.2856p PS=1.54u PD=2.36u
M$3233 D[7]|X \$1096 VDD|vdd VDD|vdd sg13_lv_pmos L=0.13u W=1.12u AS=0.42p
+ AD=0.2114p PS=2.99u PD=1.54u
M$3234 VDD|vdd A|Q|net26 \$1096 VDD|vdd sg13_lv_pmos L=0.13u W=0.84u AS=0.2114p
+ AD=0.2856p PS=1.54u PD=2.36u
M$3235 VDD|vdd A|Q|net18 \$1097 VDD|vdd sg13_lv_pmos L=0.13u W=0.84u AS=0.2114p
+ AD=0.2856p PS=1.54u PD=2.36u
M$3236 VDD|vdd \$1097 B[6]|X VDD|vdd sg13_lv_pmos L=0.13u W=1.12u AS=0.2114p
+ AD=0.42p PS=1.54u PD=2.99u
M$3237 VDD|vdd A|Q|net17 \$1098 VDD|vdd sg13_lv_pmos L=0.13u W=0.84u AS=0.2114p
+ AD=0.2856p PS=1.54u PD=2.36u
M$3238 VDD|vdd \$1098 B[5]|X VDD|vdd sg13_lv_pmos L=0.13u W=1.12u AS=0.2114p
+ AD=0.42p PS=1.54u PD=2.99u
.ENDS sar_logic
