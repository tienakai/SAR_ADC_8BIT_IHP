* NGSPICE file created from CDAC.ext - technology: ihp-sg13g2

.subckt CDAC C_MSB C6 C5 C4 C3 C2 C1 vref vo
X0 vo.t0 C6.t31 cap_cmim l=5.71u w=5.71u
X1 m5_n64_n15529# m5_n184_n15649.t39 cap_cmim l=5.71u w=5.71u
X2 vo.t1 C_MSB.t63 cap_cmim l=5.71u w=5.71u
X3 vo.t2 C_MSB.t62 cap_cmim l=5.71u w=5.71u
X4 vo.t3 C6.t30 cap_cmim l=5.71u w=5.71u
X5 vo.t4 C6.t29 cap_cmim l=5.71u w=5.71u
X6 m5_n64_n15529# m5_n184_n15649.t38 cap_cmim l=5.71u w=5.71u
X7 vo.t5 C_MSB.t61 cap_cmim l=5.71u w=5.71u
X8 vo.t6 C_MSB.t60 cap_cmim l=5.71u w=5.71u
X9 m5_n64_n15529# m5_n184_n15649.t37 cap_cmim l=5.71u w=5.71u
X10 vo.t7 C6.t28 cap_cmim l=5.71u w=5.71u
X11 vo.t8 C5.t15 cap_cmim l=5.71u w=5.71u
X12 vo.t9 C_MSB.t59 cap_cmim l=5.71u w=5.71u
X13 vo.t10 C_MSB.t58 cap_cmim l=5.71u w=5.71u
X14 m5_n64_n15529# m5_n184_n15649.t36 cap_cmim l=5.71u w=5.71u
X15 vo.t11 C_MSB.t57 cap_cmim l=5.71u w=5.71u
X16 vo.t12 C_MSB.t56 cap_cmim l=5.71u w=5.71u
X17 vo.t13 C_MSB.t55 cap_cmim l=5.71u w=5.71u
X18 vo.t14 C3.t3 cap_cmim l=5.71u w=5.71u
X19 m5_n64_n15529# m5_n184_n15649.t35 cap_cmim l=5.71u w=5.71u
X20 m5_n64_n15529# m5_n184_n15649.t34 cap_cmim l=5.71u w=5.71u
X21 vo.t15 C6.t27 cap_cmim l=5.71u w=5.71u
X22 m5_n64_n15529# m5_n184_n15649.t33 cap_cmim l=5.71u w=5.71u
X23 m5_n64_n15529# m5_n184_n15649.t32 cap_cmim l=5.71u w=5.71u
X24 vo.t16 C6.t26 cap_cmim l=5.71u w=5.71u
X25 vo.t17 C4.t7 cap_cmim l=5.71u w=5.71u
X26 vo.t18 C5.t14 cap_cmim l=5.71u w=5.71u
X27 vo.t19 C_MSB.t54 cap_cmim l=5.71u w=5.71u
X28 vo.t20 C4.t6 cap_cmim l=5.71u w=5.71u
X29 vo.t21 C_MSB.t53 cap_cmim l=5.71u w=5.71u
X30 vo.t22 C_MSB.t52 cap_cmim l=5.71u w=5.71u
X31 vo.t23 C4.t5 cap_cmim l=5.71u w=5.71u
X32 m5_n64_n15529# m5_n184_n15649.t31 cap_cmim l=5.71u w=5.71u
X33 m5_n64_n15529# m5_n184_n15649.t30 cap_cmim l=5.71u w=5.71u
X34 vo.t24 C3.t2 cap_cmim l=5.71u w=5.71u
X35 vo.t25 C_MSB.t51 cap_cmim l=5.71u w=5.71u
X36 vo.t26 C_MSB.t50 cap_cmim l=5.71u w=5.71u
X37 vo.t27 C6.t25 cap_cmim l=5.71u w=5.71u
X38 vo.t28 C4.t4 cap_cmim l=5.71u w=5.71u
X39 vo.t29 C6.t24 cap_cmim l=5.71u w=5.71u
X40 vo.t30 C_MSB.t49 cap_cmim l=5.71u w=5.71u
X41 vo.t31 C_MSB.t48 cap_cmim l=5.71u w=5.71u
X42 vo.t32 C_MSB.t47 cap_cmim l=5.71u w=5.71u
X43 m5_n64_n15529# m5_n184_n15649.t29 cap_cmim l=5.71u w=5.71u
X44 vo.t33 C_MSB.t46 cap_cmim l=5.71u w=5.71u
X45 vo.t34 C5.t13 cap_cmim l=5.71u w=5.71u
X46 vo.t35 C6.t23 cap_cmim l=5.71u w=5.71u
X47 m5_n64_n15529# m5_n184_n15649.t28 cap_cmim l=5.71u w=5.71u
X48 vo.t36 C_MSB.t45 cap_cmim l=5.71u w=5.71u
X49 vo.t37 C_MSB.t44 cap_cmim l=5.71u w=5.71u
X50 vo.t38 C3.t1 cap_cmim l=5.71u w=5.71u
X51 vo.t39 C_MSB.t43 cap_cmim l=5.71u w=5.71u
X52 vo.t40 C_MSB.t42 cap_cmim l=5.71u w=5.71u
X53 vo.t41 C6.t22 cap_cmim l=5.71u w=5.71u
X54 vo.t42 C6.t21 cap_cmim l=5.71u w=5.71u
X55 m5_n64_n15529# m5_n184_n15649.t27 cap_cmim l=5.71u w=5.71u
X56 vo.t43 C_MSB.t41 cap_cmim l=5.71u w=5.71u
X57 vo.t44 C_MSB.t40 cap_cmim l=5.71u w=5.71u
X58 m5_n64_n15529# m5_n184_n15649.t26 cap_cmim l=5.71u w=5.71u
X59 vo.t45 C6.t20 cap_cmim l=5.71u w=5.71u
X60 m5_n64_n15529# m5_n184_n15649.t25 cap_cmim l=5.71u w=5.71u
X61 m5_n64_n15529# m5_n184_n15649.t24 cap_cmim l=5.71u w=5.71u
X62 vo.t46 C_MSB.t39 cap_cmim l=5.71u w=5.71u
X63 vo.t47 C4.t3 cap_cmim l=5.71u w=5.71u
X64 vo.t48 C_MSB.t38 cap_cmim l=5.71u w=5.71u
X65 m5_n64_n15529# m5_n184_n15649.t23 cap_cmim l=5.71u w=5.71u
X66 vo.t49 C6.t19 cap_cmim l=5.71u w=5.71u
X67 vo.t50 C_MSB.t37 cap_cmim l=5.71u w=5.71u
X68 vo.t51 C_MSB.t36 cap_cmim l=5.71u w=5.71u
X69 m5_n64_n15529# m5_n184_n15649.t22 cap_cmim l=5.71u w=5.71u
X70 m5_n64_n15529# m5_n184_n15649.t21 cap_cmim l=5.71u w=5.71u
X71 vo.t52 C_MSB.t35 cap_cmim l=5.71u w=5.71u
X72 m5_n64_n15529# m5_n184_n15649.t20 cap_cmim l=5.71u w=5.71u
X73 vo.t53 C_MSB.t34 cap_cmim l=5.71u w=5.71u
X74 vo.t54 C6.t18 cap_cmim l=5.71u w=5.71u
X75 vo.t55 C6.t17 cap_cmim l=5.71u w=5.71u
X76 vo.t56 C6.t16 cap_cmim l=5.71u w=5.71u
X77 vo.t57 C5.t12 cap_cmim l=5.71u w=5.71u
X78 vo.t58 C6.t15 cap_cmim l=5.71u w=5.71u
X79 m5_n64_n15529# m5_n184_n15649.t19 cap_cmim l=5.71u w=5.71u
X80 vo.t59 C_MSB.t33 cap_cmim l=5.71u w=5.71u
X81 vo.t60 C_MSB.t32 cap_cmim l=5.71u w=5.71u
X82 m5_n64_n15529# m5_n184_n15649.t18 cap_cmim l=5.71u w=5.71u
X83 vo.t61 C_MSB.t31 cap_cmim l=5.71u w=5.71u
X84 m5_n64_n15529# m5_n184_n15649.t17 cap_cmim l=5.71u w=5.71u
X85 vo.t62 C5.t11 cap_cmim l=5.71u w=5.71u
X86 vo.t63 C5.t10 cap_cmim l=5.71u w=5.71u
X87 vo.t64 C_MSB.t30 cap_cmim l=5.71u w=5.71u
X88 m5_n64_n15529# m5_n184_n15649.t16 cap_cmim l=5.71u w=5.71u
X89 m5_n64_n15529# m5_n184_n15649.t15 cap_cmim l=5.71u w=5.71u
X90 vo.t65 C_MSB.t29 cap_cmim l=5.71u w=5.71u
X91 vo.t66 C6.t14 cap_cmim l=5.71u w=5.71u
X92 m5_n64_n15529# m5_n184_n15649.t14 cap_cmim l=5.71u w=5.71u
X93 m5_n64_n15529# m5_n184_n15649.t13 cap_cmim l=5.71u w=5.71u
X94 vo.t67 C_MSB.t28 cap_cmim l=5.71u w=5.71u
X95 vo.t68 C5.t9 cap_cmim l=5.71u w=5.71u
X96 vo.t69 C_MSB.t27 cap_cmim l=5.71u w=5.71u
X97 vo.t70 C6.t13 cap_cmim l=5.71u w=5.71u
X98 vo.t71 C_MSB.t26 cap_cmim l=5.71u w=5.71u
X99 vo.t72 C5.t8 cap_cmim l=5.71u w=5.71u
X100 vo.t73 C5.t7 cap_cmim l=5.71u w=5.71u
X101 vo.t74 C2.t1 cap_cmim l=5.71u w=5.71u
X102 vo.t75 C_MSB.t25 cap_cmim l=5.71u w=5.71u
X103 vo.t76 C5.t6 cap_cmim l=5.71u w=5.71u
X104 vo.t77 C6.t12 cap_cmim l=5.71u w=5.71u
X105 m5_n64_n15529# m5_n184_n15649.t12 cap_cmim l=5.71u w=5.71u
X106 vo.t78 C_MSB.t24 cap_cmim l=5.71u w=5.71u
X107 vo.t79 C_MSB.t23 cap_cmim l=5.71u w=5.71u
X108 vo.t80 C_MSB.t22 cap_cmim l=5.71u w=5.71u
X109 vo.t81 C6.t11 cap_cmim l=5.71u w=5.71u
X110 vo.t82 C6.t10 cap_cmim l=5.71u w=5.71u
X111 m5_n64_n15529# m5_n184_n15649.t11 cap_cmim l=5.71u w=5.71u
X112 vo.t83 C_MSB.t21 cap_cmim l=5.71u w=5.71u
X113 vo.t84 C5.t5 cap_cmim l=5.71u w=5.71u
X114 vo.t85 C_MSB.t20 cap_cmim l=5.71u w=5.71u
X115 vo.t86 C6.t9 cap_cmim l=5.71u w=5.71u
X116 m5_n64_n15529# m5_n184_n15649.t10 cap_cmim l=5.71u w=5.71u
X117 vo.t87 C6.t8 cap_cmim l=5.71u w=5.71u
X118 m5_n64_n15529# m5_n184_n15649.t9 cap_cmim l=5.71u w=5.71u
X119 vo.t88 C_MSB.t19 cap_cmim l=5.71u w=5.71u
X120 vo.t89 C1.t0 cap_cmim l=5.71u w=5.71u
X121 m5_n64_n15529# m5_n184_n15649.t8 cap_cmim l=5.71u w=5.71u
X122 vo.t90 C_MSB.t18 cap_cmim l=5.71u w=5.71u
X123 vo.t91 C3.t0 cap_cmim l=5.71u w=5.71u
X124 vo.t92 C_MSB.t17 cap_cmim l=5.71u w=5.71u
X125 vo.t93 C_MSB.t16 cap_cmim l=5.71u w=5.71u
X126 vo.t94 C_MSB.t15 cap_cmim l=5.71u w=5.71u
X127 vo.t95 C6.t7 cap_cmim l=5.71u w=5.71u
X128 vo.t96 C6.t6 cap_cmim l=5.71u w=5.71u
X129 m5_n64_n15529# m5_n184_n15649.t7 cap_cmim l=5.71u w=5.71u
X130 vo.t97 C_MSB.t14 cap_cmim l=5.71u w=5.71u
X131 vo.t98 C_MSB.t13 cap_cmim l=5.71u w=5.71u
X132 vo.t99 C4.t2 cap_cmim l=5.71u w=5.71u
X133 vo.t100 C4.t1 cap_cmim l=5.71u w=5.71u
X134 vo.t101 C2.t0 cap_cmim l=5.71u w=5.71u
X135 m5_n64_n15529# m5_n184_n15649.t6 cap_cmim l=5.71u w=5.71u
X136 vo.t102 C_MSB.t12 cap_cmim l=5.71u w=5.71u
X137 vo.t103 C_MSB.t11 cap_cmim l=5.71u w=5.71u
X138 vo.t104 C_MSB.t10 cap_cmim l=5.71u w=5.71u
X139 vo.t105 C4.t0 cap_cmim l=5.71u w=5.71u
X140 vo.t106 C_MSB.t9 cap_cmim l=5.71u w=5.71u
X141 vo.t107 vref.t0 cap_cmim l=5.71u w=5.71u
X142 vo.t108 C5.t4 cap_cmim l=5.71u w=5.71u
X143 vo.t109 C_MSB.t8 cap_cmim l=5.71u w=5.71u
X144 vo.t110 C5.t3 cap_cmim l=5.71u w=5.71u
X145 vo.t111 C_MSB.t7 cap_cmim l=5.71u w=5.71u
X146 vo.t112 C6.t5 cap_cmim l=5.71u w=5.71u
X147 vo.t113 C_MSB.t6 cap_cmim l=5.71u w=5.71u
X148 vo.t114 C6.t4 cap_cmim l=5.71u w=5.71u
X149 m5_n64_n15529# m5_n184_n15649.t5 cap_cmim l=5.71u w=5.71u
X150 vo.t115 C6.t3 cap_cmim l=5.71u w=5.71u
X151 vo.t116 C_MSB.t5 cap_cmim l=5.71u w=5.71u
X152 vo.t117 C6.t2 cap_cmim l=5.71u w=5.71u
X153 vo.t118 C6.t1 cap_cmim l=5.71u w=5.71u
X154 vo.t119 C5.t2 cap_cmim l=5.71u w=5.71u
X155 vo.t120 C_MSB.t4 cap_cmim l=5.71u w=5.71u
X156 m5_n64_n15529# m5_n184_n15649.t4 cap_cmim l=5.71u w=5.71u
X157 vo.t121 C_MSB.t3 cap_cmim l=5.71u w=5.71u
X158 vo.t122 C_MSB.t2 cap_cmim l=5.71u w=5.71u
X159 vo.t123 C5.t1 cap_cmim l=5.71u w=5.71u
X160 vo.t124 C6.t0 cap_cmim l=5.71u w=5.71u
X161 m5_n64_n15529# m5_n184_n15649.t3 cap_cmim l=5.71u w=5.71u
X162 vo.t125 C_MSB.t1 cap_cmim l=5.71u w=5.71u
X163 m5_n64_n15529# m5_n184_n15649.t2 cap_cmim l=5.71u w=5.71u
X164 m5_n64_n15529# m5_n184_n15649.t1 cap_cmim l=5.71u w=5.71u
X165 vo.t126 C5.t0 cap_cmim l=5.71u w=5.71u
X166 vo.t127 C_MSB.t0 cap_cmim l=5.71u w=5.71u
X167 m5_n64_n15529# m5_n184_n15649.t0 cap_cmim l=5.71u w=5.71u
C0 vref C5 1.59618f
C1 C1 vo 0.82233f
C2 C6 C5 27.2638f
C3 C3 C4 9.70565f
C4 C5 vo 13.7901f
C5 C2 vo 1.68979f
C6 vref C6 1.59618f
C7 C3 C2 4.81313f
C8 vref vo 0.89518f
C9 C6 vo 27.6854f
C10 m5_n64_n15529# vo 14.1177f
C11 C3 vo 3.40778f
C12 C5 C4 17.5293f
C13 C1 C5 1.59618f
C14 C2 C1 1.69181f
C15 C6 C_MSB 37.9303f
C16 m5_n64_n15529# C_MSB 1.97309f
C17 C2 C5 1.59618f
C18 vref C1 1.69432f
C19 C_MSB vo 50.0042f
C20 C4 vo 6.83661f
R0 vo.t127 vo.t36 0.0355182
R1 vo.t122 vo.t65 0.0355182
R2 vo.n92 vo.t33 0.034786
R3 vo.n27 vo.t71 0.0345055
R4 vo.n97 vo.n18 0.0344825
R5 vo.n91 vo.n24 0.0344825
R6 vo.n29 vo.t6 0.0344825
R7 vo.n21 vo.t83 0.034411
R8 vo.t53 vo.n100 0.0343914
R9 vo.t64 vo.n98 0.0342871
R10 vo.t113 vo.n105 0.034195
R11 vo.t102 vo.n103 0.034195
R12 vo.t80 vo.n104 0.0341414
R13 vo.n107 vo.t31 0.0341057
R14 vo.t106 vo.n102 0.0337692
R15 vo.t26 vo.n99 0.033695
R16 vo.t121 vo.t109 0.0336886
R17 vo.t66 vo.t56 0.0336273
R18 vo.t79 vo.t92 0.0336273
R19 vo.t41 vo.t27 0.0336273
R20 vo.t32 vo.t120 0.0336273
R21 vo.t81 vo.t7 0.0336273
R22 vo.t110 vo.t63 0.0336273
R23 vo.t1 vo.t88 0.0336273
R24 vo.t69 vo.t19 0.0336273
R25 vo.t10 vo.n106 0.0334478
R26 vo.t50 vo.n101 0.0333914
R27 vo.n84 vo.t93 0.0333058
R28 vo.t4 vo.n121 0.033288
R29 vo.n2 vo.t30 0.033288
R30 vo.n82 vo.t47 0.0331264
R31 vo.t37 vo.n13 0.0329744
R32 vo.n79 vo.t89 0.0329299
R33 vo.n113 vo.t11 0.032913
R34 vo.t114 vo.n12 0.032913
R35 vo.n69 vo.t82 0.032913
R36 vo.t44 vo.n93 0.0328951
R37 vo.n78 vo.t107 0.0328764
R38 vo.t96 vo.t8 0.0327087
R39 vo.t45 vo.t77 0.0327087
R40 vo.t35 vo.t72 0.0327087
R41 vo.t58 vo.t16 0.0327087
R42 vo.t87 vo.t54 0.0327087
R43 vo.t68 vo.t17 0.0327087
R44 vo.t74 vo.t24 0.0327087
R45 vo.t91 vo.t14 0.0327087
R46 vo.t100 vo.t20 0.0327087
R47 vo.t126 vo.t73 0.0327087
R48 vo.t0 vo.t86 0.0327087
R49 vo.t112 vo.t29 0.0327087
R50 vo.t39 vo.n9 0.0326894
R51 vo.n110 vo.n15 0.0326529
R52 vo.n11 vo.n10 0.0326529
R53 vo.n118 vo.t84 0.0326279
R54 vo.n117 vo.t115 0.0326279
R55 vo.t12 vo.n6 0.0326279
R56 vo.t111 vo.n88 0.0326101
R57 vo.n120 vo.t15 0.0326094
R58 vo.n119 vo.t123 0.0326094
R59 vo.t48 vo.n3 0.0326094
R60 vo.n111 vo.t52 0.0325994
R61 vo.n17 vo.n16 0.0325916
R62 vo.n67 vo.n66 0.0325916
R63 vo.n115 vo.n114 0.0325916
R64 vo.n109 vo.n108 0.0325916
R65 vo.t25 vo.n87 0.0325916
R66 vo.n116 vo.n8 0.0325916
R67 vo.n39 vo.n7 0.0325916
R68 vo.n96 vo.n95 0.0325916
R69 vo.n90 vo.n89 0.0325916
R70 vo.n68 vo.t98 0.032538
R71 vo.n112 vo.t22 0.032538
R72 vo.t125 vo.n14 0.032538
R73 vo.t5 vo.n94 0.0325201
R74 vo.n80 vo.t101 0.0325012
R75 vo.n83 vo.t18 0.0324299
R76 vo.n81 vo.t38 0.0321264
R77 vo.n70 vo.t42 0.0319766
R78 vo.t49 vo.n40 0.0319766
R79 vo.t117 vo.n60 0.0319766
R80 vo.n59 vo.t124 0.0319766
R81 vo.n23 vo.t3 0.0319766
R82 vo.n51 vo.t95 0.0319766
R83 vo.n54 vo.t62 0.0316893
R84 vo.t34 vo.n55 0.0316893
R85 vo.n28 vo.t70 0.0316893
R86 vo.n74 vo.t119 0.0316893
R87 vo.t108 vo.n5 0.0316893
R88 vo.t57 vo.n35 0.0316893
R89 vo.n44 vo.n43 0.031673
R90 vo.n64 vo.n63 0.031673
R91 vo.n65 vo.n42 0.031673
R92 vo.n47 vo.n46 0.031673
R93 vo.n20 vo.n19 0.031673
R94 vo.n49 vo.n48 0.031673
R95 vo.n57 vo.n56 0.031673
R96 vo.n86 vo.t118 0.031673
R97 vo.t76 vo.n30 0.031673
R98 vo.n71 vo.n37 0.031673
R99 vo.t23 vo.n4 0.031673
R100 vo.n75 vo.t28 0.031673
R101 vo.t99 vo.n34 0.031673
R102 vo.t105 vo.n53 0.031673
R103 vo.n38 vo.n36 0.031673
R104 vo.n58 vo.n52 0.031673
R105 vo.n26 vo.n25 0.031673
R106 vo.n73 vo.n72 0.031673
R107 vo.t78 vo.n45 0.0316016
R108 vo.t2 vo.n41 0.0316016
R109 vo.t9 vo.n62 0.0316016
R110 vo.n61 vo.t75 0.0316016
R111 vo.n50 vo.t60 0.0316016
R112 vo.n22 vo.t90 0.0316016
R113 vo vo.n122 0.0310341
R114 vo.t104 vo.t127 0.0263378
R115 vo.t67 vo.t61 0.0263315
R116 vo.t31 vo.t40 0.0263315
R117 vo.t61 vo.n3 0.0255343
R118 vo.n98 vo.t97 0.0246273
R119 vo.t13 vo.n107 0.0246273
R120 vo.n106 vo.t116 0.0246273
R121 vo.n105 vo.t85 0.0246273
R122 vo.t93 vo.t55 0.0245369
R123 vo.n1 vo.n0 0.024288
R124 vo.n122 vo.n0 0.0239299
R125 vo.n100 vo.t21 0.0237087
R126 vo.n101 vo.t51 0.0237087
R127 vo.n104 vo.t94 0.0237087
R128 vo.n102 vo.t43 0.0237087
R129 vo.n103 vo.t103 0.0237087
R130 vo.n99 vo.t59 0.0237087
R131 vo.n82 vo.n31 0.0233873
R132 vo.n78 vo.n77 0.0233873
R133 vo.n79 vo.n76 0.0233873
R134 vo.n80 vo.n33 0.0233873
R135 vo.n81 vo.n32 0.0233873
R136 vo.n85 vo.n83 0.0233873
R137 vo.n108 vo.n17 0.0165728
R138 vo.n64 vo.n43 0.0165728
R139 vo.n63 vo.n44 0.0165728
R140 vo.n60 vo.n40 0.0165728
R141 vo.n72 vo.n38 0.0165728
R142 vo.n62 vo.n61 0.0165728
R143 vo.n95 vo.n20 0.0165728
R144 vo.n93 vo.n23 0.0165728
R145 vo.n89 vo.n26 0.0165728
R146 vo.n113 vo.n12 0.0165728
R147 vo.n114 vo.n8 0.0165728
R148 vo.n117 vo.n6 0.0165728
R149 vo.n116 vo.n115 0.0165728
R150 vo.n120 vo.n3 0.0165728
R151 vo.n75 vo.n34 0.0165728
R152 vo.n74 vo.n35 0.0165728
R153 vo.n73 vo.n36 0.0165728
R154 vo.n112 vo.n14 0.0165728
R155 vo.n109 vo.n16 0.0165728
R156 vo.n96 vo.n19 0.0165728
R157 vo.n94 vo.n22 0.0165728
R158 vo.n90 vo.n25 0.0165728
R159 vo.n88 vo.n28 0.0165728
R160 vo.n87 vo.n86 0.0165728
R161 vo.n70 vo.n40 0.0165343
R162 vo.n66 vo.n17 0.0165343
R163 vo.n67 vo.n42 0.0165343
R164 vo.n67 vo.n16 0.0165343
R165 vo.n47 vo.n43 0.0165343
R166 vo.n65 vo.n64 0.0165343
R167 vo.n66 vo.n65 0.0165343
R168 vo.n62 vo.n41 0.0165343
R169 vo.n68 vo.n41 0.0165343
R170 vo.n63 vo.n42 0.0165343
R171 vo.n56 vo.n52 0.0165343
R172 vo.n52 vo.n36 0.0165343
R173 vo.n58 vo.n38 0.0165343
R174 vo.n59 vo.n51 0.0165343
R175 vo.n60 vo.n59 0.0165343
R176 vo.n61 vo.n45 0.0165343
R177 vo.n49 vo.n46 0.0165343
R178 vo.n46 vo.n44 0.0165343
R179 vo.n48 vo.n19 0.0165343
R180 vo.n48 vo.n47 0.0165343
R181 vo.n49 vo.n20 0.0165343
R182 vo.n50 vo.n22 0.0165343
R183 vo.n50 vo.n45 0.0165343
R184 vo.n51 vo.n23 0.0165343
R185 vo.n57 vo.n25 0.0165343
R186 vo.n58 vo.n57 0.0165343
R187 vo.n56 vo.n26 0.0165343
R188 vo.n55 vo.n28 0.0165343
R189 vo.n55 vo.n54 0.0165343
R190 vo.n112 vo.n111 0.0165343
R191 vo.n114 vo.n11 0.0165343
R192 vo.n113 vo.n13 0.0165343
R193 vo.n39 vo.n8 0.0165343
R194 vo.n74 vo.n5 0.0165343
R195 vo.n118 vo.n5 0.0165343
R196 vo.n37 vo.n7 0.0165343
R197 vo.n116 vo.n7 0.0165343
R198 vo.n118 vo.n117 0.0165343
R199 vo.n115 vo.n10 0.0165343
R200 vo.n9 vo.n6 0.0165343
R201 vo.n119 vo.n4 0.0165343
R202 vo.n120 vo.n119 0.0165343
R203 vo.n75 vo.n4 0.0165343
R204 vo.n53 vo.n30 0.0165343
R205 vo.n53 vo.n34 0.0165343
R206 vo.n54 vo.n35 0.0165343
R207 vo.n73 vo.n37 0.0165343
R208 vo.n72 vo.n71 0.0165343
R209 vo.n71 vo.n39 0.0165343
R210 vo.n70 vo.n69 0.0165343
R211 vo.n69 vo.n12 0.0165343
R212 vo.n68 vo.n14 0.0165343
R213 vo.n110 vo.n109 0.0165343
R214 vo.n108 vo.n15 0.0165343
R215 vo.n97 vo.n96 0.0165343
R216 vo.n95 vo.n18 0.0165343
R217 vo.n94 vo.n21 0.0165343
R218 vo.n93 vo.n92 0.0165343
R219 vo.n91 vo.n90 0.0165343
R220 vo.n89 vo.n24 0.0165343
R221 vo.n87 vo.n29 0.0165343
R222 vo.n88 vo.n27 0.0165343
R223 vo.n86 vo.n30 0.0165343
R224 vo.n121 vo.n2 0.0160083
R225 vo.n76 vo.n33 0.0160083
R226 vo.n85 vo.n84 0.0160083
R227 vo.n121 vo.n1 0.0159711
R228 vo.n77 vo.n76 0.0159711
R229 vo.n77 vo.n1 0.0159711
R230 vo.n33 vo.n32 0.0159711
R231 vo.n85 vo.n31 0.0159711
R232 vo.n32 vo.n31 0.0159711
R233 vo.n122 vo.t30 0.0155547
R234 vo.n101 vo.t53 0.00164286
R235 vo.t47 vo.n81 0.00164286
R236 vo.n106 vo.t113 0.001625
R237 vo.n41 vo.t42 0.00160714
R238 vo.n62 vo.t49 0.00160714
R239 vo.t124 vo.n45 0.00160714
R240 vo.n61 vo.t117 0.00160714
R241 vo.t3 vo.n22 0.00160714
R242 vo.t95 vo.n50 0.00160714
R243 vo.t33 vo.n21 0.00160714
R244 vo.n94 vo.t44 0.00160714
R245 vo.t11 vo.n112 0.00158929
R246 vo.n111 vo.t37 0.00158929
R247 vo.t82 vo.n68 0.00158929
R248 vo.n14 vo.t114 0.00158929
R249 vo.t118 vo.n28 0.00155357
R250 vo.n55 vo.t76 0.00155357
R251 vo.t28 vo.n74 0.00155357
R252 vo.n5 vo.t23 0.00155357
R253 vo.n54 vo.t105 0.00155357
R254 vo.n35 vo.t99 0.00155357
R255 vo.t6 vo.n27 0.00155357
R256 vo.n88 vo.t25 0.00155357
R257 vo.t123 vo.n118 0.00153571
R258 vo.n117 vo.t15 0.00153571
R259 vo.n6 vo.t48 0.00153571
R260 vo.n9 vo.t67 0.00153571
R261 vo.t17 vo.n4 0.00153571
R262 vo.t24 vo.n75 0.00153571
R263 vo.n34 vo.t91 0.00153571
R264 vo.t73 vo.n30 0.00153571
R265 vo.n53 vo.t100 0.00153571
R266 vo.n29 vo.t46 0.00153571
R267 vo.n87 vo.t19 0.00153571
R268 vo.n86 vo.t112 0.00153571
R269 vo.n3 vo.t32 0.00151786
R270 vo.t7 vo.n120 0.00151786
R271 vo.n119 vo.t110 0.00151786
R272 vo.n99 vo.t64 0.00133929
R273 vo.t55 vo.n83 0.00133929
R274 vo.n102 vo.t50 0.00130357
R275 vo.t38 vo.n80 0.00130357
R276 vo.n42 vo.t2 0.00126786
R277 vo.n63 vo.t9 0.00126786
R278 vo.t75 vo.n44 0.00126786
R279 vo.n46 vo.t78 0.00126786
R280 vo.t60 vo.n49 0.00126786
R281 vo.t90 vo.n20 0.00126786
R282 vo.n95 vo.t5 0.00126786
R283 vo.t83 vo.n18 0.00126786
R284 vo.t98 vo.n67 0.00125
R285 vo.t52 vo.n110 0.00125
R286 vo.n16 vo.t125 0.00125
R287 vo.n109 vo.t22 0.00125
R288 vo.n40 vo.t96 0.00123214
R289 vo.n60 vo.t35 0.00123214
R290 vo.n59 vo.t45 0.00123214
R291 vo.t16 vo.n51 0.00123214
R292 vo.t54 vo.n23 0.00123214
R293 vo.t86 vo.n70 0.00123214
R294 vo.n93 vo.t88 0.00123214
R295 vo.n92 vo.t122 0.00123214
R296 vo.n13 vo.t121 0.00121429
R297 vo.n12 vo.t66 0.00121429
R298 vo.t92 vo.n113 0.00121429
R299 vo.n69 vo.t41 0.00121429
R300 vo.t62 vo.n52 0.00119643
R301 vo.n56 vo.t34 0.00119643
R302 vo.t70 vo.n26 0.00119643
R303 vo.n37 vo.t108 0.00119643
R304 vo.n36 vo.t57 0.00119643
R305 vo.t119 vo.n73 0.00119643
R306 vo.n89 vo.t111 0.00119643
R307 vo.t71 vo.n24 0.00119643
R308 vo.n10 vo.t39 0.00117857
R309 vo.n7 vo.t84 0.00117857
R310 vo.t115 vo.n116 0.00117857
R311 vo.n115 vo.t12 0.00117857
R312 vo.n107 vo.t10 0.000928571
R313 vo.n104 vo.t102 0.000892857
R314 vo.t89 vo.n78 0.000892857
R315 vo.t109 vo.n11 0.000857143
R316 vo.n114 vo.t79 0.000857143
R317 vo.t56 vo.n8 0.000857143
R318 vo.t27 vo.n39 0.000857143
R319 vo.t77 vo.n58 0.000839286
R320 vo.t72 vo.n38 0.000839286
R321 vo.n25 vo.t87 0.000839286
R322 vo.n57 vo.t58 0.000839286
R323 vo.t120 vo.n2 0.000839286
R324 vo.n121 vo.t81 0.000839286
R325 vo.t63 vo.n1 0.000839286
R326 vo.n72 vo.t8 0.000839286
R327 vo.n71 vo.t0 0.000839286
R328 vo.n105 vo.t80 0.000839286
R329 vo.n103 vo.t106 0.000839286
R330 vo.t65 vo.n91 0.000839286
R331 vo.n90 vo.t1 0.000839286
R332 vo.t101 vo.n79 0.000839286
R333 vo.t107 vo.n0 0.000839286
R334 vo.n77 vo.t68 0.000821429
R335 vo.n76 vo.t74 0.000821429
R336 vo.t14 vo.n33 0.000821429
R337 vo.t20 vo.n32 0.000821429
R338 vo.n31 vo.t126 0.000821429
R339 vo.t29 vo.n85 0.000821429
R340 vo.n84 vo.t69 0.000821429
R341 vo.t116 vo.n17 0.000785714
R342 vo.n66 vo.t85 0.000785714
R343 vo.n108 vo.t13 0.000785714
R344 vo.t40 vo.n15 0.000785714
R345 vo.n98 vo.t104 0.000785714
R346 vo.n43 vo.t43 0.000767857
R347 vo.n64 vo.t103 0.000767857
R348 vo.n65 vo.t94 0.000767857
R349 vo.n47 vo.t51 0.000767857
R350 vo.n19 vo.t59 0.000767857
R351 vo.n48 vo.t21 0.000767857
R352 vo.t36 vo.n97 0.000767857
R353 vo.n96 vo.t97 0.000767857
R354 vo.n122 vo.t4 0.00075
R355 vo.n100 vo.t26 0.000642857
R356 vo.t18 vo.n82 0.000642857
R357 C6.n24 C6.n23 0.404567
R358 C6.n42 C6.n15 0.388433
R359 C6.n11 C6.n9 0.382567
R360 C6.n34 C6.n17 0.3657
R361 C6.n67 C6.n1 0.346633
R362 C6.n21 C6.n20 0.345167
R363 C6.n27 C6.n22 0.342233
R364 C6.n33 C6.n32 0.3371
R365 C6.n51 C6.n8 0.336367
R366 C6.n64 C6.n2 0.3327
R367 C6.n14 C6.n13 0.331233
R368 C6.n69 C6.n0 0.3261
R369 C6.n39 C6.n38 0.3261
R370 C6.n36 C6.n16 0.3217
R371 C6.n46 C6.n45 0.304833
R372 C6.n48 C6.n47 0.3019
R373 C6.n60 C6.n4 0.293833
R374 C6.n62 C6.n3 0.2733
R375 C6.n30 C6.n28 0.263033
R376 C6.n54 C6.n7 0.2579
R377 C6.n56 C6.n6 0.254233
R378 C6.n58 C6.n5 0.249833
R379 C6.n50 C6.n49 0.0352459
R380 C6.n66 C6.n65 0.0332218
R381 C6.t3 C6.t27 0.0328089
R382 C6.t1 C6.t13 0.032805
R383 C6.t11 C6.t29 0.0326913
R384 C6.t28 C6.t11 0.0326913
R385 C6.t27 C6.t28 0.0326913
R386 C6.t5 C6.t1 0.0326873
R387 C6.t24 C6.t5 0.0326873
R388 C6.t17 C6.t24 0.0326873
R389 C6.n53 C6.n52 0.032363
R390 C6.n44 C6.n43 0.0322504
R391 C6.n36 C6.n35 0.030278
R392 C6.n38 C6.n37 0.0301981
R393 C6.n31 C6.n30 0.0266822
R394 C6.n65 C6.n64 0.0266232
R395 C6.n52 C6.n51 0.0263835
R396 C6.n68 C6.n67 0.0263667
R397 C6.n29 C6.n0 0.0262262
R398 C6.n48 C6.t3 0.0261251
R399 C6.t13 C6.n69 0.0261231
R400 C6.n59 C6.n58 0.0257677
R401 C6.n57 C6.n56 0.0257229
R402 C6.n43 C6.n42 0.0257112
R403 C6.n55 C6.n54 0.0257092
R404 C6.n61 C6.n60 0.0256627
R405 C6.n63 C6.n62 0.0256532
R406 C6.n32 C6.n31 0.0253968
R407 C6 C6.t17 0.0231599
R408 C6.n23 C6.n1 0.0220673
R409 C6.n22 C6.n21 0.0220673
R410 C6.n34 C6.n33 0.0220673
R411 C6.n15 C6.n14 0.0220673
R412 C6.n11 C6.n8 0.0220673
R413 C6.n28 C6.n27 0.0201364
R414 C6.n24 C6.n2 0.0201364
R415 C6.n16 C6.n5 0.0195588
R416 C6.n39 C6.n6 0.0190143
R417 C6.n45 C6.n9 0.0189903
R418 C6.n13 C6.n7 0.0189903
R419 C6.n17 C6.n4 0.0185
R420 C6.n47 C6.n46 0.0180135
R421 C6.n20 C6.n3 0.0180135
R422 C6.n50 C6.n8 0.00863948
R423 C6.n26 C6.n23 0.00824728
R424 C6.n40 C6.n15 0.00821805
R425 C6.n12 C6.n11 0.00821508
R426 C6.n14 C6.n10 0.00820384
R427 C6.n41 C6.n38 0.00820065
R428 C6.n21 C6.n19 0.00819943
R429 C6.n68 C6.n0 0.00818355
R430 C6.n33 C6.n18 0.00818235
R431 C6.n66 C6.n1 0.00818211
R432 C6.n25 C6.n22 0.00817276
R433 C6.n29 C6.n28 0.00813573
R434 C6.n37 C6.n16 0.0079791
R435 C6.n32 C6.n19 0.00794849
R436 C6.t23 C6.n34 0.00790763
R437 C6.t6 C6.n36 0.00790763
R438 C6.n45 C6.n44 0.00774459
R439 C6.n27 C6.n26 0.00766123
R440 C6.n35 C6.n17 0.00760846
R441 C6.n25 C6.n24 0.00759274
R442 C6.n63 C6.n2 0.00753808
R443 C6.n49 C6.n47 0.00744519
R444 C6.n57 C6.n5 0.00744038
R445 C6.n40 C6.n39 0.00729773
R446 C6.n13 C6.n12 0.00728831
R447 C6.n42 C6.n41 0.00728255
R448 C6.n10 C6.n9 0.00727851
R449 C6.n55 C6.n6 0.00726285
R450 C6.n53 C6.n7 0.00725099
R451 C6.t16 C6.n48 0.00714046
R452 C6.n51 C6.t14 0.00714046
R453 C6.n67 C6.t18 0.00713958
R454 C6.n69 C6.t8 0.00713958
R455 C6.n59 C6.n4 0.00704882
R456 C6.n30 C6.t15 0.00696891
R457 C6.n56 C6.t21 0.00696679
R458 C6.n58 C6.t19 0.00696679
R459 C6.n60 C6.t2 0.00696679
R460 C6.n62 C6.t0 0.00696679
R461 C6.n64 C6.t7 0.00696679
R462 C6.n54 C6.t10 0.00696663
R463 C6.n20 C6.n18 0.00695791
R464 C6.n61 C6.n3 0.00690972
R465 C6.n46 C6.t25 0.00665163
R466 C6.n31 C6.t12 0.00211363
R467 C6.t14 C6.n50 0.00164285
R468 C6.n35 C6.t23 0.00163815
R469 C6.n49 C6.t16 0.00163649
R470 C6.n44 C6.t25 0.00163534
R471 C6.t15 C6.n29 0.00161841
R472 C6.n37 C6.t6 0.00161683
R473 C6.n65 C6.t30 0.00117704
R474 C6.t8 C6.n68 0.00117631
R475 C6.t7 C6.n63 0.00116908
R476 C6.t2 C6.n59 0.00116262
R477 C6.t0 C6.n61 0.00115603
R478 C6.n52 C6.t4 0.00115579
R479 C6.t26 C6.n25 0.00115345
R480 C6.n19 C6.t20 0.00114788
R481 C6.t18 C6.n66 0.00114613
R482 C6.t20 C6.n18 0.00114092
R483 C6.t10 C6.n53 0.0011392
R484 C6.n43 C6.t31 0.00113863
R485 C6.t21 C6.n55 0.0011367
R486 C6.n41 C6.t9 0.00113629
R487 C6.t22 C6.n10 0.00113478
R488 C6.t19 C6.n57 0.00113147
R489 C6.n12 C6.t22 0.00112954
R490 C6.t9 C6.n40 0.00112819
R491 C6.n26 C6.t26 0.00111776
R492 m5_n184_n15649.n5 m5_n184_n15649.n0 0.4207
R493 m5_n184_n15649.n11 m5_n184_n15649.n6 0.279167
R494 m5_n184_n15649.n15 m5_n184_n15649.n14 0.0958888
R495 m5_n184_n15649.n9 m5_n184_n15649.n8 0.0501184
R496 m5_n184_n15649.n3 m5_n184_n15649.n2 0.0415275
R497 m5_n184_n15649.n13 m5_n184_n15649.t12 0.0407033
R498 m5_n184_n15649.n4 m5_n184_n15649.n3 0.0406195
R499 m5_n184_n15649.n2 m5_n184_n15649.n1 0.0406021
R500 m5_n184_n15649.t31 m5_n184_n15649.n13 0.0402911
R501 m5_n184_n15649.t8 m5_n184_n15649.t30 0.0401007
R502 m5_n184_n15649.t35 m5_n184_n15649.t31 0.0399548
R503 m5_n184_n15649.t30 m5_n184_n15649.t34 0.0399548
R504 m5_n184_n15649.t18 m5_n184_n15649.t8 0.0399548
R505 m5_n184_n15649.t6 m5_n184_n15649.t18 0.0399548
R506 m5_n184_n15649.t2 m5_n184_n15649.t6 0.0399548
R507 m5_n184_n15649.t38 m5_n184_n15649.t2 0.0399548
R508 m5_n184_n15649.t17 m5_n184_n15649.t11 0.0391051
R509 m5_n184_n15649.t28 m5_n184_n15649.t7 0.039104
R510 m5_n184_n15649.t9 m5_n184_n15649.t20 0.039104
R511 m5_n184_n15649.t11 m5_n184_n15649.t5 0.038967
R512 m5_n184_n15649.t29 m5_n184_n15649.t17 0.038967
R513 m5_n184_n15649.t10 m5_n184_n15649.t29 0.0389664
R514 m5_n184_n15649.t7 m5_n184_n15649.t10 0.0389658
R515 m5_n184_n15649.t26 m5_n184_n15649.t28 0.0389658
R516 m5_n184_n15649.t32 m5_n184_n15649.t26 0.0389658
R517 m5_n184_n15649.t20 m5_n184_n15649.t32 0.0389658
R518 m5_n184_n15649.t12 m5_n184_n15649.t9 0.0389658
R519 m5_n184_n15649.t5 m5_n184_n15649.n12 0.0385729
R520 m5_n184_n15649.n10 m5_n184_n15649.n9 0.0377818
R521 m5_n184_n15649.n12 m5_n184_n15649.t24 0.0349576
R522 m5_n184_n15649.t22 m5_n184_n15649.t16 0.0347358
R523 m5_n184_n15649.t16 m5_n184_n15649.t13 0.0346108
R524 m5_n184_n15649.t4 m5_n184_n15649.t22 0.0346108
R525 m5_n184_n15649.t0 m5_n184_n15649.t4 0.0346108
R526 m5_n184_n15649.t23 m5_n184_n15649.t0 0.0346108
R527 m5_n184_n15649.t27 m5_n184_n15649.t23 0.0346108
R528 m5_n184_n15649.t21 m5_n184_n15649.t27 0.0346108
R529 m5_n184_n15649.t24 m5_n184_n15649.t21 0.0346108
R530 m5_n184_n15649.n8 m5_n184_n15649.n7 0.0343342
R531 m5_n184_n15649.n14 m5_n184_n15649.t35 0.0338632
R532 m5_n184_n15649.n7 m5_n184_n15649.n6 0.0329587
R533 m5_n184_n15649.t34 m5_n184_n15649.n5 0.0320483
R534 m5_n184_n15649.n1 m5_n184_n15649.n0 0.0317423
R535 m5_n184_n15649.t13 m5_n184_n15649.n11 0.0276804
R536 m5_n184_n15649.n10 m5_n184_n15649.n6 0.00915073
R537 m5_n184_n15649.n5 m5_n184_n15649.t3 0.00849784
R538 m5_n184_n15649.n4 m5_n184_n15649.n0 0.00839884
R539 m5_n184_n15649.n14 m5_n184_n15649.t38 0.00759154
R540 m5_n184_n15649.n11 m5_n184_n15649.t37 0.0075088
R541 m5_n184_n15649.n9 m5_n184_n15649.t14 0.00211382
R542 m5_n184_n15649.n2 m5_n184_n15649.t25 0.00210767
R543 m5_n184_n15649.n1 m5_n184_n15649.t39 0.00209946
R544 m5_n184_n15649.t37 m5_n184_n15649.n10 0.00163697
R545 m5_n184_n15649.n8 m5_n184_n15649.t19 0.00115001
R546 m5_n184_n15649.n3 m5_n184_n15649.t1 0.0011408
R547 m5_n184_n15649.n13 m5_n184_n15649.t33 0.00113181
R548 m5_n184_n15649.n12 m5_n184_n15649.t15 0.00112066
R549 m5_n184_n15649.t3 m5_n184_n15649.n4 0.00112062
R550 m5_n184_n15649.n7 m5_n184_n15649.t36 0.00110273
R551 C_MSB.n109 C_MSB.n1 0.535833
R552 C_MSB.n19 C_MSB.n18 0.527033
R553 C_MSB.n85 C_MSB.n46 0.492567
R554 C_MSB.n28 C_MSB.n26 0.491833
R555 C_MSB.n105 C_MSB.n3 0.487433
R556 C_MSB.n111 C_MSB.n0 0.483767
R557 C_MSB.n103 C_MSB.n4 0.465433
R558 C_MSB.n101 C_MSB.n5 0.4625
R559 C_MSB.n107 C_MSB.n2 0.458833
R560 C_MSB.n91 C_MSB.n90 0.455167
R561 C_MSB.n75 C_MSB.n51 0.455167
R562 C_MSB.n43 C_MSB.n13 0.450767
R563 C_MSB.n73 C_MSB.n52 0.4493
R564 C_MSB.n81 C_MSB.n48 0.448567
R565 C_MSB.n32 C_MSB.n24 0.443433
R566 C_MSB.n77 C_MSB.n50 0.4427
R567 C_MSB.n79 C_MSB.n49 0.436833
R568 C_MSB.n34 C_MSB.n23 0.421433
R569 C_MSB.n36 C_MSB.n22 0.4185
R570 C_MSB.n64 C_MSB.n54 0.417033
R571 C_MSB.n30 C_MSB.n25 0.414833
R572 C_MSB.n66 C_MSB.n53 0.411167
R573 C_MSB.n99 C_MSB.n6 0.408967
R574 C_MSB.n62 C_MSB.n55 0.404567
R575 C_MSB.n40 C_MSB.n20 0.402367
R576 C_MSB.n60 C_MSB.n56 0.3987
R577 C_MSB.n94 C_MSB.n11 0.395033
R578 C_MSB.n88 C_MSB.n45 0.377433
R579 C_MSB.n82 C_MSB.n47 0.373033
R580 C_MSB.n93 C_MSB.n12 0.3723
R581 C_MSB.n38 C_MSB.n21 0.364967
R582 C_MSB.n59 C_MSB.n57 0.359833
R583 C_MSB.n97 C_MSB.n8 0.3547
R584 C_MSB.n96 C_MSB.n9 0.335633
R585 C_MSB.n16 C_MSB.n15 0.333433
R586 C_MSB.n70 C_MSB.n68 0.3107
R587 C_MSB.n42 C_MSB.n41 0.0440838
R588 C_MSB.t41 C_MSB.t11 0.0430754
R589 C_MSB.t33 C_MSB.t53 0.0429215
R590 C_MSB.t53 C_MSB.t36 0.0429215
R591 C_MSB.t36 C_MSB.t41 0.0429215
R592 C_MSB.t11 C_MSB.t15 0.0429215
R593 C_MSB.t15 C_MSB.t20 0.0429205
R594 C_MSB.t20 C_MSB.t5 0.0429196
R595 C_MSB.n84 C_MSB.n83 0.0405379
R596 C_MSB.n72 C_MSB.n71 0.0399889
R597 C_MSB.t16 C_MSB.t27 0.03671
R598 C_MSB.n28 C_MSB.n27 0.0362127
R599 C_MSB.t25 C_MSB.t59 0.0357256
R600 C_MSB.t59 C_MSB.t62 0.0356006
R601 C_MSB.t24 C_MSB.t25 0.0356006
R602 C_MSB.t32 C_MSB.t24 0.0356006
R603 C_MSB.t18 C_MSB.t32 0.0356006
R604 C_MSB.t62 C_MSB.t13 0.0356003
R605 C_MSB.t13 C_MSB.t1 0.0356
R606 C_MSB.n30 C_MSB.n29 0.0353268
R607 C_MSB.n40 C_MSB.n39 0.035254
R608 C_MSB.n32 C_MSB.n31 0.0352368
R609 C_MSB.n38 C_MSB.n37 0.035234
R610 C_MSB.n36 C_MSB.n35 0.0352317
R611 C_MSB.n34 C_MSB.n33 0.0352137
R612 C_MSB.n69 C_MSB.t4 0.0349276
R613 C_MSB.n91 C_MSB.t5 0.0348252
R614 C_MSB.t4 C_MSB.t49 0.034565
R615 C_MSB.t30 C_MSB.n44 0.0341072
R616 C_MSB.n16 C_MSB.t33 0.0338261
R617 C_MSB.t9 C_MSB.t37 0.033805
R618 C_MSB.t6 C_MSB.t22 0.0336877
R619 C_MSB.t22 C_MSB.t12 0.0336875
R620 C_MSB.t12 C_MSB.t9 0.0336873
R621 C_MSB.t37 C_MSB.t34 0.0336873
R622 C_MSB.t34 C_MSB.t50 0.0336873
R623 C_MSB.t50 C_MSB.t30 0.0336873
R624 C_MSB.n87 C_MSB.n86 0.0333708
R625 C_MSB.n74 C_MSB.n73 0.0313125
R626 C_MSB.n78 C_MSB.n77 0.0311868
R627 C_MSB.n76 C_MSB.n75 0.031183
R628 C_MSB.n27 C_MSB.n0 0.0311604
R629 C_MSB.n71 C_MSB.n70 0.031112
R630 C_MSB.n86 C_MSB.n85 0.0307251
R631 C_MSB.n80 C_MSB.n79 0.0306836
R632 C_MSB.n108 C_MSB.n107 0.0303179
R633 C_MSB.n106 C_MSB.n105 0.0302291
R634 C_MSB.n100 C_MSB.n99 0.0302272
R635 C_MSB.n102 C_MSB.n101 0.0302258
R636 C_MSB.n104 C_MSB.n103 0.0302141
R637 C_MSB.n110 C_MSB.n109 0.0297222
R638 C_MSB.t27 C_MSB.n111 0.029405
R639 C_MSB.n97 C_MSB.t18 0.0288003
R640 C_MSB C_MSB.t16 0.0285659
R641 C_MSB.n58 C_MSB.n9 0.0284631
R642 C_MSB.n66 C_MSB.n65 0.0280675
R643 C_MSB.n62 C_MSB.n61 0.0279557
R644 C_MSB.n64 C_MSB.n63 0.0279517
R645 C_MSB.n68 C_MSB.n67 0.027947
R646 C_MSB.t1 C_MSB.n96 0.0278
R647 C_MSB.n43 C_MSB.n42 0.0274194
R648 C_MSB.n45 C_MSB.t6 0.0262409
R649 C_MSB.n20 C_MSB.n19 0.0254231
R650 C_MSB.n46 C_MSB.n12 0.0254231
R651 C_MSB.n82 C_MSB.n81 0.0228448
R652 C_MSB.n56 C_MSB.n49 0.0224661
R653 C_MSB.n55 C_MSB.n50 0.0224661
R654 C_MSB.n54 C_MSB.n51 0.0224661
R655 C_MSB.n53 C_MSB.n52 0.0224661
R656 C_MSB.n57 C_MSB.n48 0.0224661
R657 C_MSB.n26 C_MSB.n1 0.0224661
R658 C_MSB.n25 C_MSB.n2 0.0224661
R659 C_MSB.n24 C_MSB.n3 0.0224661
R660 C_MSB.n23 C_MSB.n4 0.0224661
R661 C_MSB.n22 C_MSB.n5 0.0224661
R662 C_MSB.n15 C_MSB.n8 0.0221
R663 C_MSB.n18 C_MSB.n13 0.0221
R664 C_MSB.n47 C_MSB.n11 0.02075
R665 C_MSB.n21 C_MSB.n6 0.02075
R666 C_MSB.n60 C_MSB.n59 0.0207213
R667 C_MSB.n94 C_MSB.n93 0.0207213
R668 C_MSB.n90 C_MSB.n88 0.0207213
R669 C_MSB.n84 C_MSB.n46 0.00954195
R670 C_MSB.n110 C_MSB.n0 0.00932318
R671 C_MSB.n80 C_MSB.n48 0.00929496
R672 C_MSB.n89 C_MSB.n12 0.00917685
R673 C_MSB.n41 C_MSB.n20 0.00916821
R674 C_MSB.n19 C_MSB.n14 0.00916586
R675 C_MSB.n17 C_MSB.n16 0.00914394
R676 C_MSB.t45 C_MSB.n40 0.00914378
R677 C_MSB.t21 C_MSB.n38 0.00914378
R678 C_MSB.t46 C_MSB.n36 0.00914378
R679 C_MSB.t2 C_MSB.n34 0.00914378
R680 C_MSB.t29 C_MSB.n32 0.00914378
R681 C_MSB.t26 C_MSB.n30 0.00914378
R682 C_MSB.t60 C_MSB.n28 0.00914378
R683 C_MSB.n92 C_MSB.n91 0.00911815
R684 C_MSB.n106 C_MSB.n2 0.00887991
R685 C_MSB.n100 C_MSB.n5 0.00887788
R686 C_MSB.n102 C_MSB.n4 0.00887609
R687 C_MSB.n104 C_MSB.n3 0.00885738
R688 C_MSB.n58 C_MSB.n57 0.00885341
R689 C_MSB.n78 C_MSB.n49 0.00884612
R690 C_MSB.n76 C_MSB.n50 0.00884069
R691 C_MSB.n72 C_MSB.n52 0.00883376
R692 C_MSB.n74 C_MSB.n51 0.00882685
R693 C_MSB.n108 C_MSB.n1 0.0087789
R694 C_MSB.n10 C_MSB.n9 0.00874953
R695 C_MSB.n83 C_MSB.n47 0.00835606
R696 C_MSB.n70 C_MSB.n69 0.00832991
R697 C_MSB.n31 C_MSB.n25 0.00832689
R698 C_MSB.n61 C_MSB.n56 0.00832487
R699 C_MSB.n37 C_MSB.n22 0.00832428
R700 C_MSB.n35 C_MSB.n23 0.00832201
R701 C_MSB.n63 C_MSB.n55 0.00831883
R702 C_MSB.n67 C_MSB.n53 0.00831117
R703 C_MSB.n65 C_MSB.n54 0.00830359
R704 C_MSB.n33 C_MSB.n24 0.00829947
R705 C_MSB.n8 C_MSB.n7 0.00825116
R706 C_MSB.n15 C_MSB.n14 0.00821917
R707 C_MSB.n29 C_MSB.n26 0.00821068
R708 C_MSB.n18 C_MSB.n17 0.00819979
R709 C_MSB.n44 C_MSB.n13 0.00817698
R710 C_MSB.n79 C_MSB.t3 0.00813437
R711 C_MSB.n77 C_MSB.t8 0.00813437
R712 C_MSB.n75 C_MSB.t43 0.00813437
R713 C_MSB.n73 C_MSB.t28 0.00813437
R714 C_MSB.n81 C_MSB.t44 0.00813437
R715 C_MSB.t35 C_MSB.n82 0.00813437
R716 C_MSB.n85 C_MSB.t42 0.00813437
R717 C_MSB.n99 C_MSB.n98 0.00812609
R718 C_MSB.n109 C_MSB.t51 0.00788249
R719 C_MSB.n107 C_MSB.t7 0.00788249
R720 C_MSB.n105 C_MSB.t63 0.00788249
R721 C_MSB.n103 C_MSB.t19 0.00788249
R722 C_MSB.n101 C_MSB.t40 0.00788249
R723 C_MSB.n111 C_MSB.t54 0.00788249
R724 C_MSB.n7 C_MSB.n6 0.00786893
R725 C_MSB.n90 C_MSB.n89 0.00784489
R726 C_MSB.n96 C_MSB.n95 0.00783777
R727 C_MSB.n95 C_MSB.n94 0.0078343
R728 C_MSB.n88 C_MSB.n87 0.0078302
R729 C_MSB.n39 C_MSB.n21 0.0078292
R730 C_MSB.n93 C_MSB.n92 0.00779576
R731 C_MSB.n11 C_MSB.n10 0.00777576
R732 C_MSB.n98 C_MSB.n97 0.00775045
R733 C_MSB.n59 C_MSB.t57 0.00749967
R734 C_MSB.t47 C_MSB.n68 0.00749967
R735 C_MSB.t38 C_MSB.n66 0.00749967
R736 C_MSB.t56 C_MSB.n64 0.00749967
R737 C_MSB.t23 C_MSB.n62 0.00749967
R738 C_MSB.t17 C_MSB.n60 0.00749967
R739 C_MSB.t58 C_MSB.n45 0.00713301
R740 C_MSB.t10 C_MSB.n43 0.00713274
R741 C_MSB.n27 C_MSB.t39 0.00213942
R742 C_MSB.n71 C_MSB.t31 0.00213701
R743 C_MSB.t42 C_MSB.n84 0.00164869
R744 C_MSB.t43 C_MSB.n74 0.00163609
R745 C_MSB.t28 C_MSB.n72 0.00163411
R746 C_MSB.t51 C_MSB.n108 0.00163377
R747 C_MSB.t8 C_MSB.n76 0.00163193
R748 C_MSB.t3 C_MSB.n78 0.00163005
R749 C_MSB.t63 C_MSB.n104 0.00161922
R750 C_MSB.t57 C_MSB.n58 0.00161896
R751 C_MSB.n83 C_MSB.t35 0.00161399
R752 C_MSB.t19 C_MSB.n102 0.00161336
R753 C_MSB.t40 C_MSB.n100 0.00161261
R754 C_MSB.t7 C_MSB.n106 0.00161168
R755 C_MSB.n29 C_MSB.t60 0.00118517
R756 C_MSB.n98 C_MSB.t61 0.00117079
R757 C_MSB.n10 C_MSB.t52 0.00116504
R758 C_MSB.n33 C_MSB.t29 0.00116388
R759 C_MSB.n35 C_MSB.t2 0.0011555
R760 C_MSB.t44 C_MSB.n80 0.00115531
R761 C_MSB.n37 C_MSB.t46 0.00115444
R762 C_MSB.n92 C_MSB.t55 0.00115427
R763 C_MSB.n31 C_MSB.t26 0.00115312
R764 C_MSB.n42 C_MSB.t0 0.00115168
R765 C_MSB.n17 C_MSB.t14 0.00114723
R766 C_MSB.n41 C_MSB.t45 0.00114632
R767 C_MSB.n65 C_MSB.t56 0.00114493
R768 C_MSB.n67 C_MSB.t38 0.00114271
R769 C_MSB.n44 C_MSB.t10 0.00114112
R770 C_MSB.n63 C_MSB.t23 0.00114028
R771 C_MSB.n39 C_MSB.t21 0.00113951
R772 C_MSB.t54 C_MSB.n110 0.00113942
R773 C_MSB.n61 C_MSB.t17 0.00113817
R774 C_MSB.t14 C_MSB.n14 0.00113694
R775 C_MSB.n89 C_MSB.t55 0.00112752
R776 C_MSB.n95 C_MSB.t52 0.00112246
R777 C_MSB.n87 C_MSB.t58 0.00112043
R778 C_MSB.n86 C_MSB.t48 0.00111815
R779 C_MSB.n69 C_MSB.t47 0.00111176
R780 C_MSB.n7 C_MSB.t61 0.00110995
R781 C5.n6 C5.n3 0.2535
R782 C5.n8 C5.n0 0.142428
R783 C5.n4 C5.t9 0.0333089
R784 C5.t3 C5.n4 0.0331455
R785 C5.n2 C5.n1 0.0327413
R786 C5.n10 C5.t11 0.0323921
R787 C5.n5 C5.t1 0.0322444
R788 C5.t1 C5.t3 0.0317788
R789 C5.t11 C5.n9 0.0309716
R790 C5.t4 C5.n5 0.0305135
R791 C5.t6 C5.n10 0.0298076
R792 C5.n3 C5.n2 0.0297262
R793 C5.n1 C5.n0 0.0297023
R794 C5.t7 C5.t6 0.0294274
R795 C5.t0 C5.t7 0.0294274
R796 C5.t14 C5.t0 0.0294274
R797 C5.n8 C5.n7 0.0287699
R798 C5.n6 C5.t4 0.0250715
R799 C5 C5.t14 0.0230635
R800 C5.n9 C5.n0 0.00893228
R801 C5.n7 C5.n3 0.00871576
R802 C5.t2 C5.n6 0.00664455
R803 C5.t12 C5.n8 0.00384175
R804 C5.n4 C5.t10 0.00207162
R805 C5.n9 C5.t12 0.0016211
R806 C5.n7 C5.t2 0.00160156
R807 C5.n10 C5.t13 0.00115523
R808 C5.n1 C5.t8 0.00115253
R809 C5.n2 C5.t15 0.00110368
R810 C5.n5 C5.t5 0.00110279
R811 C3.n0 C3.t2 0.0341126
R812 C3.t3 C3.n0 0.0304548
R813 C3.t1 C3.t3 0.0301853
R814 C3 C3.t1 0.0184473
R815 C3.n0 C3.t0 0.00115829
R816 C4.n1 C4.t2 0.0338698
R817 C4.t2 C4.t4 0.0328979
R818 C4.t4 C4.n0 0.0320677
R819 C4.t1 C4.n1 0.0318857
R820 C4.t3 C4.t6 0.0317607
R821 C4.t6 C4.t1 0.0317607
R822 C4.n0 C4.t7 0.027056
R823 C4 C4.t3 0.0263362
R824 C4.n1 C4.t0 0.00123805
R825 C4.n0 C4.t5 0.00113396
R826 C2.t0 C2.t1 0.0294282
R827 C2 C2.t0 0.0225537
R828 C1 C1.t0 0.022796
R829 vref vref.t0 0.0203361
C21 vref sub 0.6559f
C22 C1 sub 0.55095f
C23 C2 sub 1.64631f
C24 C3 sub 2.96288f
C25 C4 sub 3.94715f
C26 C5 sub 4.84379f
C27 C6 sub 6.37649f
C28 vo sub 6.38733p
C29 C_MSB sub 10.47521f
C30 m5_n64_n15529# sub 2.00458p $ **FLOATING
C31 C2.t1 sub 1.37269f $ **FLOATING
C32 C2.t0 sub 2.47223f $ **FLOATING
C33 C4.t0 sub 1.25678f $ **FLOATING
C34 C4.t5 sub 1.13241f $ **FLOATING
C35 C4.t7 sub 3.55869f $ **FLOATING
C36 C4.n0 sub 2.57772f $ **FLOATING
C37 C4.t4 sub 3.59698f $ **FLOATING
C38 C4.t2 sub 3.65916f $ **FLOATING
C39 C4.n1 sub 2.46181f $ **FLOATING
C40 C4.t1 sub 3.62348f $ **FLOATING
C41 C4.t6 sub 3.65303f $ **FLOATING
C42 C4.t3 sub 5.98364f $ **FLOATING
C43 C3.t0 sub 1.07538f $ **FLOATING
C44 C3.t2 sub 3.20965f $ **FLOATING
C45 C3.n0 sub 2.28041f $ **FLOATING
C46 C3.t3 sub 3.29886f $ **FLOATING
C47 C3.t1 sub 6.02127f $ **FLOATING
C48 C5.t13 sub 1.05886f $ **FLOATING
C49 C5.n0 sub 1.18745f $ **FLOATING
C50 C5.t8 sub 1.12299f $ **FLOATING
C51 C5.n1 sub 1.91074f $ **FLOATING
C52 C5.t15 sub 1.07283f $ **FLOATING
C53 C5.n2 sub 2.00402f $ **FLOATING
C54 C5.n3 sub 1.18998f $ **FLOATING
C55 C5.t5 sub 1.03424f $ **FLOATING
C56 C5.t9 sub 3.25016f $ **FLOATING
C57 C5.t10 sub 1.02346f $ **FLOATING
C58 C5.n4 sub 2.3f $ **FLOATING
C59 C5.t3 sub 3.36631f $ **FLOATING
C60 C5.t1 sub 3.32757f $ **FLOATING
C61 C5.n5 sub 2.33289f $ **FLOATING
C62 C5.t4 sub 2.97681f $ **FLOATING
C63 C5.n6 sub 1.49924f $ **FLOATING
C64 C5.t2 sub 0.16864f $ **FLOATING
C65 C5.n7 sub 1.06756f $ **FLOATING
C66 C5.n8 sub 1.30436f $ **FLOATING
C67 C5.t12 sub 0.16864f $ **FLOATING
C68 C5.n9 sub 1.17195f $ **FLOATING
C69 C5.t11 sub 3.33686f $ **FLOATING
C70 C5.n10 sub 2.3361f $ **FLOATING
C71 C5.t6 sub 3.34112f $ **FLOATING
C72 C5.t7 sub 3.35442f $ **FLOATING
C73 C5.t0 sub 3.35442f $ **FLOATING
C74 C5.t14 sub 6.04171f $ **FLOATING
C75 C_MSB.n0 sub 0.86502f $ **FLOATING
C76 C_MSB.n1 sub 0.66528f $ **FLOATING
C77 C_MSB.n2 sub 0.66454f $ **FLOATING
C78 C_MSB.n3 sub 0.66464f $ **FLOATING
C79 C_MSB.n4 sub 0.66455f $ **FLOATING
C80 C_MSB.n5 sub 0.66454f $ **FLOATING
C81 C_MSB.n6 sub 0.68682f $ **FLOATING
C82 C_MSB.n8 sub 0.64793f $ **FLOATING
C83 C_MSB.n9 sub 0.83328f $ **FLOATING
C84 C_MSB.n11 sub 0.64092f $ **FLOATING
C85 C_MSB.n12 sub 0.58804f $ **FLOATING
C86 C_MSB.t5 sub 1.98333f $ **FLOATING
C87 C_MSB.n13 sub 0.63756f $ **FLOATING
C88 C_MSB.n15 sub 0.63484f $ **FLOATING
C89 C_MSB.t20 sub 2.16568f $ **FLOATING
C90 C_MSB.t15 sub 2.16565f $ **FLOATING
C91 C_MSB.t11 sub 2.16661f $ **FLOATING
C92 C_MSB.t41 sub 2.16669f $ **FLOATING
C93 C_MSB.t36 sub 2.16567f $ **FLOATING
C94 C_MSB.t53 sub 2.16567f $ **FLOATING
C95 C_MSB.t33 sub 1.96513f $ **FLOATING
C96 C_MSB.n16 sub 0.74825f $ **FLOATING
C97 C_MSB.n18 sub 0.68396f $ **FLOATING
C98 C_MSB.n19 sub 0.63385f $ **FLOATING
C99 C_MSB.n20 sub 0.60654f $ **FLOATING
C100 C_MSB.n21 sub 0.65949f $ **FLOATING
C101 C_MSB.n22 sub 0.6372f $ **FLOATING
C102 C_MSB.n23 sub 0.63721f $ **FLOATING
C103 C_MSB.n24 sub 0.63731f $ **FLOATING
C104 C_MSB.n25 sub 0.6372f $ **FLOATING
C105 C_MSB.n26 sub 0.63802f $ **FLOATING
C106 C_MSB.t39 sub 0.80217f $ **FLOATING
C107 C_MSB.n27 sub 0.98588f $ **FLOATING
C108 C_MSB.n28 sub 0.87336f $ **FLOATING
C109 C_MSB.t60 sub 0.23491f $ **FLOATING
C110 C_MSB.n29 sub 0.48316f $ **FLOATING
C111 C_MSB.n30 sub 0.83172f $ **FLOATING
C112 C_MSB.t26 sub 0.23491f $ **FLOATING
C113 C_MSB.n31 sub 0.49883f $ **FLOATING
C114 C_MSB.n32 sub 0.84719f $ **FLOATING
C115 C_MSB.t29 sub 0.23491f $ **FLOATING
C116 C_MSB.n33 sub 0.49252f $ **FLOATING
C117 C_MSB.n34 sub 0.83786f $ **FLOATING
C118 C_MSB.t2 sub 0.23491f $ **FLOATING
C119 C_MSB.n35 sub 0.49738f $ **FLOATING
C120 C_MSB.n36 sub 0.83895f $ **FLOATING
C121 C_MSB.t46 sub 0.23491f $ **FLOATING
C122 C_MSB.n37 sub 0.49802f $ **FLOATING
C123 C_MSB.n38 sub 0.82251f $ **FLOATING
C124 C_MSB.t21 sub 0.22924f $ **FLOATING
C125 C_MSB.n39 sub 0.50077f $ **FLOATING
C126 C_MSB.n40 sub 0.83555f $ **FLOATING
C127 C_MSB.t45 sub 0.24286f $ **FLOATING
C128 C_MSB.n41 sub 0.6843f $ **FLOATING
C129 C_MSB.t0 sub 0.76416f $ **FLOATING
C130 C_MSB.n42 sub 1.19989f $ **FLOATING
C131 C_MSB.n43 sub 0.978f $ **FLOATING
C132 C_MSB.t10 sub 0.11684f $ **FLOATING
C133 C_MSB.n44 sub 0.76026f $ **FLOATING
C134 C_MSB.t30 sub 2.18129f $ **FLOATING
C135 C_MSB.t50 sub 2.19108f $ **FLOATING
C136 C_MSB.t34 sub 2.19108f $ **FLOATING
C137 C_MSB.t37 sub 2.19233f $ **FLOATING
C138 C_MSB.t9 sub 2.19242f $ **FLOATING
C139 C_MSB.t12 sub 2.19108f $ **FLOATING
C140 C_MSB.t22 sub 2.19108f $ **FLOATING
C141 C_MSB.t6 sub 1.96041f $ **FLOATING
C142 C_MSB.n45 sub 0.94698f $ **FLOATING
C143 C_MSB.t58 sub 0.11266f $ **FLOATING
C144 C_MSB.t48 sub 0.73281f $ **FLOATING
C145 C_MSB.n46 sub 0.61205f $ **FLOATING
C146 C_MSB.n47 sub 0.665f $ **FLOATING
C147 C_MSB.n48 sub 0.64279f $ **FLOATING
C148 C_MSB.n49 sub 0.64274f $ **FLOATING
C149 C_MSB.n50 sub 0.64276f $ **FLOATING
C150 C_MSB.n51 sub 0.64284f $ **FLOATING
C151 C_MSB.n52 sub 0.6428f $ **FLOATING
C152 C_MSB.n53 sub 0.61874f $ **FLOATING
C153 C_MSB.n54 sub 0.61879f $ **FLOATING
C154 C_MSB.n55 sub 0.6187f $ **FLOATING
C155 C_MSB.n56 sub 0.61867f $ **FLOATING
C156 C_MSB.n57 sub 0.61873f $ **FLOATING
C157 C_MSB.n58 sub 0.53422f $ **FLOATING
C158 C_MSB.t57 sub 0.1511f $ **FLOATING
C159 C_MSB.n59 sub 0.72316f $ **FLOATING
C160 C_MSB.n60 sub 0.73517f $ **FLOATING
C161 C_MSB.t17 sub 0.1511f $ **FLOATING
C162 C_MSB.n61 sub 0.5353f $ **FLOATING
C163 C_MSB.n62 sub 0.92847f $ **FLOATING
C164 C_MSB.t23 sub 0.1511f $ **FLOATING
C165 C_MSB.n63 sub 0.53403f $ **FLOATING
C166 C_MSB.n64 sub 0.93171f $ **FLOATING
C167 C_MSB.t56 sub 0.1511f $ **FLOATING
C168 C_MSB.n65 sub 0.53309f $ **FLOATING
C169 C_MSB.n66 sub 0.9294f $ **FLOATING
C170 C_MSB.t38 sub 0.1511f $ **FLOATING
C171 C_MSB.n67 sub 0.53261f $ **FLOATING
C172 C_MSB.n68 sub 0.8979f $ **FLOATING
C173 C_MSB.t49 sub 2.13396f $ **FLOATING
C174 C_MSB.t4 sub 2.18311f $ **FLOATING
C175 C_MSB.t47 sub 0.1511f $ **FLOATING
C176 C_MSB.n69 sub 0.75538f $ **FLOATING
C177 C_MSB.n70 sub 0.82001f $ **FLOATING
C178 C_MSB.t31 sub 0.78547f $ **FLOATING
C179 C_MSB.n71 sub 1.18498f $ **FLOATING
C180 C_MSB.n72 sub 0.70069f $ **FLOATING
C181 C_MSB.t28 sub 0.17175f $ **FLOATING
C182 C_MSB.n73 sub 0.90077f $ **FLOATING
C183 C_MSB.n74 sub 0.5071f $ **FLOATING
C184 C_MSB.t43 sub 0.17175f $ **FLOATING
C185 C_MSB.n75 sub 0.90321f $ **FLOATING
C186 C_MSB.n76 sub 0.50815f $ **FLOATING
C187 C_MSB.t8 sub 0.17175f $ **FLOATING
C188 C_MSB.n77 sub 0.89996f $ **FLOATING
C189 C_MSB.n78 sub 0.50942f $ **FLOATING
C190 C_MSB.t3 sub 0.17175f $ **FLOATING
C191 C_MSB.n79 sub 0.88872f $ **FLOATING
C192 C_MSB.n80 sub 0.51521f $ **FLOATING
C193 C_MSB.t44 sub 0.17175f $ **FLOATING
C194 C_MSB.n81 sub 0.71157f $ **FLOATING
C195 C_MSB.n82 sub 0.6881f $ **FLOATING
C196 C_MSB.t35 sub 0.16608f $ **FLOATING
C197 C_MSB.n83 sub 0.72222f $ **FLOATING
C198 C_MSB.n84 sub 0.68446f $ **FLOATING
C199 C_MSB.t42 sub 0.17969f $ **FLOATING
C200 C_MSB.n85 sub 0.90775f $ **FLOATING
C201 C_MSB.n86 sub 1.26471f $ **FLOATING
C202 C_MSB.n87 sub 0.73991f $ **FLOATING
C203 C_MSB.n88 sub 0.6549f $ **FLOATING
C204 C_MSB.n90 sub 0.70225f $ **FLOATING
C205 C_MSB.n91 sub 0.7896f $ **FLOATING
C206 C_MSB.n93 sub 0.65218f $ **FLOATING
C207 C_MSB.n94 sub 0.6662f $ **FLOATING
C208 C_MSB.n96 sub 0.84535f $ **FLOATING
C209 C_MSB.t1 sub 1.96158f $ **FLOATING
C210 C_MSB.t13 sub 2.18474f $ **FLOATING
C211 C_MSB.t62 sub 2.18472f $ **FLOATING
C212 C_MSB.t59 sub 2.18598f $ **FLOATING
C213 C_MSB.t25 sub 2.1859f $ **FLOATING
C214 C_MSB.t24 sub 2.18473f $ **FLOATING
C215 C_MSB.t32 sub 2.18473f $ **FLOATING
C216 C_MSB.t18 sub 1.98512f $ **FLOATING
C217 C_MSB.n97 sub 0.83891f $ **FLOATING
C218 C_MSB.n99 sub 0.806f $ **FLOATING
C219 C_MSB.n100 sub 0.517f $ **FLOATING
C220 C_MSB.t40 sub 0.13515f $ **FLOATING
C221 C_MSB.n101 sub 0.90828f $ **FLOATING
C222 C_MSB.n102 sub 0.51637f $ **FLOATING
C223 C_MSB.t19 sub 0.13515f $ **FLOATING
C224 C_MSB.n103 sub 0.90711f $ **FLOATING
C225 C_MSB.n104 sub 0.51159f $ **FLOATING
C226 C_MSB.t63 sub 0.13515f $ **FLOATING
C227 C_MSB.n105 sub 0.91655f $ **FLOATING
C228 C_MSB.n106 sub 0.51779f $ **FLOATING
C229 C_MSB.t7 sub 0.13515f $ **FLOATING
C230 C_MSB.n107 sub 0.90099f $ **FLOATING
C231 C_MSB.n108 sub 0.50261f $ **FLOATING
C232 C_MSB.t51 sub 0.13515f $ **FLOATING
C233 C_MSB.n109 sub 0.92024f $ **FLOATING
C234 C_MSB.n110 sub 0.52105f $ **FLOATING
C235 C_MSB.t54 sub 0.13515f $ **FLOATING
C236 C_MSB.n111 sub 0.9187f $ **FLOATING
C237 C_MSB.t27 sub 1.98023f $ **FLOATING
C238 C_MSB.t16 sub 3.56674f $ **FLOATING
C239 m5_n184_n15649.n0 sub 0.78698f $ **FLOATING
C240 m5_n184_n15649.t1 sub 0.6977f $ **FLOATING
C241 m5_n184_n15649.t39 sub 0.68615f $ **FLOATING
C242 m5_n184_n15649.n1 sub 1.11563f $ **FLOATING
C243 m5_n184_n15649.t25 sub 0.69628f $ **FLOATING
C244 m5_n184_n15649.n2 sub 1.29067f $ **FLOATING
C245 m5_n184_n15649.n3 sub 1.28264f $ **FLOATING
C246 m5_n184_n15649.n4 sub 0.63689f $ **FLOATING
C247 m5_n184_n15649.t3 sub 0.15997f $ **FLOATING
C248 m5_n184_n15649.n5 sub 0.79221f $ **FLOATING
C249 m5_n184_n15649.t34 sub 1.80287f $ **FLOATING
C250 m5_n184_n15649.t30 sub 1.9775f $ **FLOATING
C251 m5_n184_n15649.t8 sub 1.9775f $ **FLOATING
C252 m5_n184_n15649.t18 sub 1.97656f $ **FLOATING
C253 m5_n184_n15649.t6 sub 1.97656f $ **FLOATING
C254 m5_n184_n15649.t2 sub 1.97656f $ **FLOATING
C255 m5_n184_n15649.t38 sub 1.25098f $ **FLOATING
C256 m5_n184_n15649.t33 sub 0.68718f $ **FLOATING
C257 m5_n184_n15649.t15 sub 0.67707f $ **FLOATING
C258 m5_n184_n15649.n6 sub 0.6981f $ **FLOATING
C259 m5_n184_n15649.t36 sub 0.66158f $ **FLOATING
C260 m5_n184_n15649.n7 sub 1.16644f $ **FLOATING
C261 m5_n184_n15649.t19 sub 0.70655f $ **FLOATING
C262 m5_n184_n15649.n8 sub 1.27892f $ **FLOATING
C263 m5_n184_n15649.t14 sub 0.70881f $ **FLOATING
C264 m5_n184_n15649.n9 sub 1.28162f $ **FLOATING
C265 m5_n184_n15649.n10 sub 0.69147f $ **FLOATING
C266 m5_n184_n15649.t37 sub 0.14514f $ **FLOATING
C267 m5_n184_n15649.n11 sub 0.82175f $ **FLOATING
C268 m5_n184_n15649.t13 sub 1.80371f $ **FLOATING
C269 m5_n184_n15649.t16 sub 1.99095f $ **FLOATING
C270 m5_n184_n15649.t22 sub 1.99095f $ **FLOATING
C271 m5_n184_n15649.t4 sub 1.98985f $ **FLOATING
C272 m5_n184_n15649.t0 sub 1.98985f $ **FLOATING
C273 m5_n184_n15649.t23 sub 1.98985f $ **FLOATING
C274 m5_n184_n15649.t27 sub 1.98985f $ **FLOATING
C275 m5_n184_n15649.t21 sub 1.98985f $ **FLOATING
C276 m5_n184_n15649.t24 sub 1.9863f $ **FLOATING
C277 m5_n184_n15649.n12 sub 1.3228f $ **FLOATING
C278 m5_n184_n15649.t5 sub 1.95643f $ **FLOATING
C279 m5_n184_n15649.t11 sub 1.98207f $ **FLOATING
C280 m5_n184_n15649.t17 sub 1.98199f $ **FLOATING
C281 m5_n184_n15649.t29 sub 1.98102f $ **FLOATING
C282 m5_n184_n15649.t10 sub 1.98104f $ **FLOATING
C283 m5_n184_n15649.t7 sub 1.98207f $ **FLOATING
C284 m5_n184_n15649.t28 sub 1.98199f $ **FLOATING
C285 m5_n184_n15649.t26 sub 1.98103f $ **FLOATING
C286 m5_n184_n15649.t32 sub 1.98103f $ **FLOATING
C287 m5_n184_n15649.t20 sub 1.98207f $ **FLOATING
C288 m5_n184_n15649.t9 sub 1.98199f $ **FLOATING
C289 m5_n184_n15649.t12 sub 1.9965f $ **FLOATING
C290 m5_n184_n15649.n13 sub 1.30477f $ **FLOATING
C291 m5_n184_n15649.t31 sub 1.97162f $ **FLOATING
C292 m5_n184_n15649.t35 sub 1.84115f $ **FLOATING
C293 m5_n184_n15649.n14 sub 0.66551f $ **FLOATING
C294 m5_n184_n15649.n15 sub 0.19548f $ **FLOATING
C295 C6.n0 sub 1.0677f $ **FLOATING
C296 C6.n1 sub 0.74624f $ **FLOATING
C297 C6.t30 sub 0.92652f $ **FLOATING
C298 C6.n2 sub 0.7711f $ **FLOATING
C299 C6.n3 sub 0.81641f $ **FLOATING
C300 C6.n4 sub 0.80509f $ **FLOATING
C301 C6.n5 sub 0.78231f $ **FLOATING
C302 C6.n6 sub 0.79348f $ **FLOATING
C303 C6.n7 sub 0.79333f $ **FLOATING
C304 C6.t4 sub 0.92338f $ **FLOATING
C305 C6.n8 sub 0.75349f $ **FLOATING
C306 C6.t25 sub 0.12829f $ **FLOATING
C307 C6.n9 sub 0.86573f $ **FLOATING
C308 C6.n11 sub 0.77612f $ **FLOATING
C309 C6.n13 sub 0.85157f $ **FLOATING
C310 C6.n14 sub 0.74926f $ **FLOATING
C311 C6.n15 sub 0.78024f $ **FLOATING
C312 C6.n16 sub 0.83935f $ **FLOATING
C313 C6.n17 sub 0.86207f $ **FLOATING
C314 C6.n20 sub 0.87337f $ **FLOATING
C315 C6.n21 sub 0.76128f $ **FLOATING
C316 C6.n22 sub 0.74259f $ **FLOATING
C317 C6.n23 sub 0.80874f $ **FLOATING
C318 C6.n24 sub 0.82813f $ **FLOATING
C319 C6.n27 sub 0.84342f $ **FLOATING
C320 C6.n28 sub 0.78121f $ **FLOATING
C321 C6.n29 sub 0.68328f $ **FLOATING
C322 C6.t15 sub 0.17108f $ **FLOATING
C323 C6.n30 sub 1.1873f $ **FLOATING
C324 C6.t12 sub 0.88698f $ **FLOATING
C325 C6.n31 sub 1.31828f $ **FLOATING
C326 C6.n32 sub 1.16843f $ **FLOATING
C327 C6.n33 sub 0.73832f $ **FLOATING
C328 C6.n34 sub 0.87861f $ **FLOATING
C329 C6.t23 sub 0.20655f $ **FLOATING
C330 C6.n35 sub 0.62553f $ **FLOATING
C331 C6.n36 sub 1.09489f $ **FLOATING
C332 C6.t6 sub 0.21224f $ **FLOATING
C333 C6.n37 sub 0.64486f $ **FLOATING
C334 C6.n38 sub 0.98874f $ **FLOATING
C335 C6.n39 sub 0.85054f $ **FLOATING
C336 C6.n42 sub 1.11043f $ **FLOATING
C337 C6.t31 sub 0.87796f $ **FLOATING
C338 C6.n43 sub 1.61472f $ **FLOATING
C339 C6.n44 sub 0.96064f $ **FLOATING
C340 C6.n45 sub 0.80465f $ **FLOATING
C341 C6.n46 sub 0.95529f $ **FLOATING
C342 C6.n47 sub 0.83113f $ **FLOATING
C343 C6.t29 sub 2.68045f $ **FLOATING
C344 C6.t11 sub 2.7482f $ **FLOATING
C345 C6.t28 sub 2.7482f $ **FLOATING
C346 C6.t27 sub 2.74981f $ **FLOATING
C347 C6.t3 sub 2.48649f $ **FLOATING
C348 C6.n48 sub 1.18375f $ **FLOATING
C349 C6.t16 sub 0.1599f $ **FLOATING
C350 C6.n49 sub 0.94475f $ **FLOATING
C351 C6.n50 sub 0.9067f $ **FLOATING
C352 C6.t14 sub 0.1797f $ **FLOATING
C353 C6.n51 sub 1.17248f $ **FLOATING
C354 C6.n52 sub 1.59151f $ **FLOATING
C355 C6.n53 sub 0.93012f $ **FLOATING
C356 C6.t10 sub 0.17543f $ **FLOATING
C357 C6.n54 sub 1.16829f $ **FLOATING
C358 C6.n55 sub 0.68702f $ **FLOATING
C359 C6.t21 sub 0.17499f $ **FLOATING
C360 C6.n56 sub 1.16898f $ **FLOATING
C361 C6.n57 sub 0.69265f $ **FLOATING
C362 C6.t19 sub 0.17784f $ **FLOATING
C363 C6.n58 sub 1.15798f $ **FLOATING
C364 C6.n59 sub 0.6739f $ **FLOATING
C365 C6.t2 sub 0.17215f $ **FLOATING
C366 C6.n60 sub 1.17584f $ **FLOATING
C367 C6.n61 sub 0.67272f $ **FLOATING
C368 C6.t0 sub 0.1693f $ **FLOATING
C369 C6.n62 sub 1.16781f $ **FLOATING
C370 C6.n63 sub 0.67457f $ **FLOATING
C371 C6.t7 sub 0.18068f $ **FLOATING
C372 C6.n64 sub 1.21718f $ **FLOATING
C373 C6.n65 sub 1.56396f $ **FLOATING
C374 C6.n66 sub 0.92606f $ **FLOATING
C375 C6.t18 sub 0.18654f $ **FLOATING
C376 C6.n67 sub 1.18107f $ **FLOATING
C377 C6.n68 sub 0.6708f $ **FLOATING
C378 C6.t8 sub 0.17244f $ **FLOATING
C379 C6.n69 sub 1.19682f $ **FLOATING
C380 C6.t13 sub 2.48654f $ **FLOATING
C381 C6.t1 sub 2.74981f $ **FLOATING
C382 C6.t5 sub 2.7482f $ **FLOATING
C383 C6.t24 sub 2.7482f $ **FLOATING
C384 C6.t17 sub 4.67708f $ **FLOATING
C385 vo.n0 sub 0.23664f $ **FLOATING
C386 vo.t30 sub 0.55832f $ **FLOATING
C387 vo.n1 sub 0.22731f $ **FLOATING
C388 vo.n2 sub 0.23816f $ **FLOATING
C389 vo.t120 sub 0.64694f $ **FLOATING
C390 vo.t32 sub 0.65338f $ **FLOATING
C391 vo.n3 sub 0.30973f $ **FLOATING
C392 vo.t15 sub 0.64735f $ **FLOATING
C393 vo.n4 sub 0.26965f $ **FLOATING
C394 vo.t63 sub 0.64694f $ **FLOATING
C395 vo.t110 sub 0.65338f $ **FLOATING
C396 vo.t23 sub 0.64939f $ **FLOATING
C397 vo.n5 sub 0.26968f $ **FLOATING
C398 vo.t84 sub 0.64394f $ **FLOATING
C399 vo.t48 sub 0.64735f $ **FLOATING
C400 vo.n6 sub 0.26731f $ **FLOATING
C401 vo.n7 sub 0.26619f $ **FLOATING
C402 vo.n8 sub 0.2654f $ **FLOATING
C403 vo.t61 sub 0.83426f $ **FLOATING
C404 vo.t67 sub 0.62372f $ **FLOATING
C405 vo.n9 sub 0.23442f $ **FLOATING
C406 vo.t39 sub 0.64382f $ **FLOATING
C407 vo.n10 sub 0.23339f $ **FLOATING
C408 vo.t12 sub 0.64394f $ **FLOATING
C409 vo.n11 sub 0.23254f $ **FLOATING
C410 vo.t56 sub 0.64711f $ **FLOATING
C411 vo.t66 sub 0.6505f $ **FLOATING
C412 vo.n12 sub 0.26835f $ **FLOATING
C413 vo.t109 sub 0.64697f $ **FLOATING
C414 vo.t121 sub 0.65036f $ **FLOATING
C415 vo.n13 sub 0.23547f $ **FLOATING
C416 vo.t114 sub 0.64968f $ **FLOATING
C417 vo.n14 sub 0.26704f $ **FLOATING
C418 vo.t22 sub 0.64421f $ **FLOATING
C419 vo.t37 sub 0.64956f $ **FLOATING
C420 vo.n15 sub 0.23235f $ **FLOATING
C421 vo.t125 sub 0.64421f $ **FLOATING
C422 vo.n16 sub 0.26646f $ **FLOATING
C423 vo.n17 sub 0.26521f $ **FLOATING
C424 vo.t116 sub 0.60168f $ **FLOATING
C425 vo.t85 sub 0.60168f $ **FLOATING
C426 vo.t94 sub 0.60111f $ **FLOATING
C427 vo.t103 sub 0.60111f $ **FLOATING
C428 vo.t43 sub 0.60111f $ **FLOATING
C429 vo.t51 sub 0.60111f $ **FLOATING
C430 vo.t21 sub 0.60111f $ **FLOATING
C431 vo.t59 sub 0.60111f $ **FLOATING
C432 vo.t97 sub 0.60151f $ **FLOATING
C433 vo.n18 sub 0.22971f $ **FLOATING
C434 vo.n19 sub 0.26727f $ **FLOATING
C435 vo.n20 sub 0.26887f $ **FLOATING
C436 vo.t83 sub 0.64093f $ **FLOATING
C437 vo.n21 sub 0.22991f $ **FLOATING
C438 vo.t90 sub 0.64623f $ **FLOATING
C439 vo.n22 sub 0.2695f $ **FLOATING
C440 vo.t3 sub 0.6518f $ **FLOATING
C441 vo.n23 sub 0.2707f $ **FLOATING
C442 vo.t88 sub 0.65067f $ **FLOATING
C443 vo.n24 sub 0.22958f $ **FLOATING
C444 vo.t54 sub 0.65291f $ **FLOATING
C445 vo.t87 sub 0.64918f $ **FLOATING
C446 vo.n25 sub 0.2675f $ **FLOATING
C447 vo.n26 sub 0.26864f $ **FLOATING
C448 vo.t71 sub 0.64063f $ **FLOATING
C449 vo.n27 sub 0.23019f $ **FLOATING
C450 vo.t70 sub 0.64598f $ **FLOATING
C451 vo.n28 sub 0.26975f $ **FLOATING
C452 vo.t46 sub 0.61895f $ **FLOATING
C453 vo.t6 sub 0.64403f $ **FLOATING
C454 vo.n29 sub 0.23019f $ **FLOATING
C455 vo.t19 sub 0.65355f $ **FLOATING
C456 vo.n30 sub 0.26965f $ **FLOATING
C457 vo.t73 sub 0.65579f $ **FLOATING
C458 vo.t126 sub 0.64901f $ **FLOATING
C459 vo.n31 sub 0.22704f $ **FLOATING
C460 vo.n32 sub 0.22704f $ **FLOATING
C461 vo.n33 sub 0.22712f $ **FLOATING
C462 vo.t14 sub 0.64901f $ **FLOATING
C463 vo.t91 sub 0.65579f $ **FLOATING
C464 vo.n34 sub 0.26973f $ **FLOATING
C465 vo.t99 sub 0.64939f $ **FLOATING
C466 vo.n35 sub 0.26975f $ **FLOATING
C467 vo.t57 sub 0.64598f $ **FLOATING
C468 vo.n36 sub 0.26864f $ **FLOATING
C469 vo.t108 sub 0.64598f $ **FLOATING
C470 vo.n37 sub 0.26856f $ **FLOATING
C471 vo.n38 sub 0.2675f $ **FLOATING
C472 vo.t8 sub 0.64918f $ **FLOATING
C473 vo.n39 sub 0.26532f $ **FLOATING
C474 vo.t96 sub 0.65291f $ **FLOATING
C475 vo.n40 sub 0.2707f $ **FLOATING
C476 vo.t42 sub 0.6518f $ **FLOATING
C477 vo.t27 sub 0.64711f $ **FLOATING
C478 vo.t41 sub 0.6505f $ **FLOATING
C479 vo.n41 sub 0.26942f $ **FLOATING
C480 vo.t2 sub 0.64623f $ **FLOATING
C481 vo.n42 sub 0.26879f $ **FLOATING
C482 vo.n43 sub 0.26727f $ **FLOATING
C483 vo.n44 sub 0.26887f $ **FLOATING
C484 vo.t49 sub 0.6518f $ **FLOATING
C485 vo.n45 sub 0.26942f $ **FLOATING
C486 vo.t72 sub 0.64918f $ **FLOATING
C487 vo.t35 sub 0.65291f $ **FLOATING
C488 vo.t78 sub 0.64623f $ **FLOATING
C489 vo.n46 sub 0.26879f $ **FLOATING
C490 vo.n47 sub 0.26719f $ **FLOATING
C491 vo.n48 sub 0.26719f $ **FLOATING
C492 vo.n49 sub 0.26879f $ **FLOATING
C493 vo.t60 sub 0.64623f $ **FLOATING
C494 vo.n50 sub 0.26942f $ **FLOATING
C495 vo.t95 sub 0.6518f $ **FLOATING
C496 vo.n51 sub 0.27063f $ **FLOATING
C497 vo.n52 sub 0.26856f $ **FLOATING
C498 vo.t20 sub 0.64901f $ **FLOATING
C499 vo.t100 sub 0.65579f $ **FLOATING
C500 vo.n53 sub 0.26965f $ **FLOATING
C501 vo.t105 sub 0.64939f $ **FLOATING
C502 vo.t62 sub 0.64598f $ **FLOATING
C503 vo.n54 sub 0.26968f $ **FLOATING
C504 vo.t76 sub 0.64939f $ **FLOATING
C505 vo.n55 sub 0.26968f $ **FLOATING
C506 vo.t34 sub 0.64598f $ **FLOATING
C507 vo.n56 sub 0.26856f $ **FLOATING
C508 vo.t16 sub 0.65291f $ **FLOATING
C509 vo.t58 sub 0.64918f $ **FLOATING
C510 vo.n57 sub 0.26742f $ **FLOATING
C511 vo.n58 sub 0.26742f $ **FLOATING
C512 vo.t77 sub 0.64918f $ **FLOATING
C513 vo.t45 sub 0.65291f $ **FLOATING
C514 vo.t124 sub 0.6518f $ **FLOATING
C515 vo.n59 sub 0.27063f $ **FLOATING
C516 vo.n60 sub 0.2707f $ **FLOATING
C517 vo.t117 sub 0.6518f $ **FLOATING
C518 vo.t75 sub 0.64623f $ **FLOATING
C519 vo.n61 sub 0.2695f $ **FLOATING
C520 vo.n62 sub 0.2695f $ **FLOATING
C521 vo.t9 sub 0.64623f $ **FLOATING
C522 vo.n63 sub 0.26887f $ **FLOATING
C523 vo.n64 sub 0.26727f $ **FLOATING
C524 vo.n65 sub 0.26719f $ **FLOATING
C525 vo.n66 sub 0.26513f $ **FLOATING
C526 vo.n67 sub 0.26638f $ **FLOATING
C527 vo.t98 sub 0.64421f $ **FLOATING
C528 vo.n68 sub 0.26696f $ **FLOATING
C529 vo.t82 sub 0.64968f $ **FLOATING
C530 vo.n69 sub 0.26827f $ **FLOATING
C531 vo.n70 sub 0.27063f $ **FLOATING
C532 vo.t86 sub 0.65291f $ **FLOATING
C533 vo.t0 sub 0.64918f $ **FLOATING
C534 vo.n71 sub 0.26742f $ **FLOATING
C535 vo.n72 sub 0.2675f $ **FLOATING
C536 vo.n73 sub 0.26864f $ **FLOATING
C537 vo.t119 sub 0.64598f $ **FLOATING
C538 vo.n74 sub 0.26975f $ **FLOATING
C539 vo.t28 sub 0.64939f $ **FLOATING
C540 vo.n75 sub 0.26973f $ **FLOATING
C541 vo.t24 sub 0.65579f $ **FLOATING
C542 vo.t74 sub 0.64901f $ **FLOATING
C543 vo.n76 sub 0.22712f $ **FLOATING
C544 vo.t17 sub 0.65579f $ **FLOATING
C545 vo.t68 sub 0.64901f $ **FLOATING
C546 vo.n77 sub 0.22704f $ **FLOATING
C547 vo.t107 sub 0.64533f $ **FLOATING
C548 vo.n78 sub 0.28697f $ **FLOATING
C549 vo.t89 sub 0.64617f $ **FLOATING
C550 vo.n79 sub 0.28715f $ **FLOATING
C551 vo.t101 sub 0.64288f $ **FLOATING
C552 vo.n80 sub 0.28569f $ **FLOATING
C553 vo.t38 sub 0.64513f $ **FLOATING
C554 vo.n81 sub 0.28446f $ **FLOATING
C555 vo.t47 sub 0.65451f $ **FLOATING
C556 vo.n82 sub 0.28778f $ **FLOATING
C557 vo.t18 sub 0.64071f $ **FLOATING
C558 vo.n83 sub 0.28549f $ **FLOATING
C559 vo.t55 sub 0.60931f $ **FLOATING
C560 vo.t93 sub 0.89134f $ **FLOATING
C561 vo.t69 sub 0.64678f $ **FLOATING
C562 vo.n84 sub 0.23822f $ **FLOATING
C563 vo.n85 sub 0.22712f $ **FLOATING
C564 vo.t29 sub 0.64901f $ **FLOATING
C565 vo.t112 sub 0.65579f $ **FLOATING
C566 vo.t118 sub 0.64939f $ **FLOATING
C567 vo.n86 sub 0.26973f $ **FLOATING
C568 vo.n87 sub 0.26723f $ **FLOATING
C569 vo.t25 sub 0.64741f $ **FLOATING
C570 vo.n88 sub 0.26725f $ **FLOATING
C571 vo.t111 sub 0.644f $ **FLOATING
C572 vo.n89 sub 0.26631f $ **FLOATING
C573 vo.t1 sub 0.64694f $ **FLOATING
C574 vo.n90 sub 0.26535f $ **FLOATING
C575 vo.n91 sub 0.22894f $ **FLOATING
C576 vo.t65 sub 0.6431f $ **FLOATING
C577 vo.t122 sub 0.64683f $ **FLOATING
C578 vo.t33 sub 0.64623f $ **FLOATING
C579 vo.n92 sub 0.23138f $ **FLOATING
C580 vo.n93 sub 0.26828f $ **FLOATING
C581 vo.t44 sub 0.64974f $ **FLOATING
C582 vo.n94 sub 0.26698f $ **FLOATING
C583 vo.t5 sub 0.64427f $ **FLOATING
C584 vo.n95 sub 0.26651f $ **FLOATING
C585 vo.n96 sub 0.26516f $ **FLOATING
C586 vo.n97 sub 0.22881f $ **FLOATING
C587 vo.t36 sub 0.64242f $ **FLOATING
C588 vo.t127 sub 0.87832f $ **FLOATING
C589 vo.t104 sub 0.60946f $ **FLOATING
C590 vo.n98 sub 0.28184f $ **FLOATING
C591 vo.t64 sub 0.64811f $ **FLOATING
C592 vo.n99 sub 0.28463f $ **FLOATING
C593 vo.t26 sub 0.63818f $ **FLOATING
C594 vo.n100 sub 0.28715f $ **FLOATING
C595 vo.t53 sub 0.65176f $ **FLOATING
C596 vo.n101 sub 0.2835f $ **FLOATING
C597 vo.t50 sub 0.6427f $ **FLOATING
C598 vo.n102 sub 0.28484f $ **FLOATING
C599 vo.t106 sub 0.64034f $ **FLOATING
C600 vo.n103 sub 0.28645f $ **FLOATING
C601 vo.t102 sub 0.64348f $ **FLOATING
C602 vo.n104 sub 0.28626f $ **FLOATING
C603 vo.t80 sub 0.64266f $ **FLOATING
C604 vo.n105 sub 0.28157f $ **FLOATING
C605 vo.t113 sub 0.65043f $ **FLOATING
C606 vo.n106 sub 0.27876f $ **FLOATING
C607 vo.t10 sub 0.63933f $ **FLOATING
C608 vo.t40 sub 0.6166f $ **FLOATING
C609 vo.t31 sub 0.87415f $ **FLOATING
C610 vo.n107 sub 0.28125f $ **FLOATING
C611 vo.t13 sub 0.60168f $ **FLOATING
C612 vo.n108 sub 0.26521f $ **FLOATING
C613 vo.n109 sub 0.26646f $ **FLOATING
C614 vo.n110 sub 0.23358f $ **FLOATING
C615 vo.t52 sub 0.64409f $ **FLOATING
C616 vo.n111 sub 0.23416f $ **FLOATING
C617 vo.n112 sub 0.26704f $ **FLOATING
C618 vo.t11 sub 0.64968f $ **FLOATING
C619 vo.n113 sub 0.26835f $ **FLOATING
C620 vo.t92 sub 0.6505f $ **FLOATING
C621 vo.t79 sub 0.64711f $ **FLOATING
C622 vo.n114 sub 0.2654f $ **FLOATING
C623 vo.n115 sub 0.26627f $ **FLOATING
C624 vo.n116 sub 0.26627f $ **FLOATING
C625 vo.t115 sub 0.64394f $ **FLOATING
C626 vo.n117 sub 0.26731f $ **FLOATING
C627 vo.n118 sub 0.26723f $ **FLOATING
C628 vo.t123 sub 0.64735f $ **FLOATING
C629 vo.n119 sub 0.26721f $ **FLOATING
C630 vo.n120 sub 0.26729f $ **FLOATING
C631 vo.t7 sub 0.65338f $ **FLOATING
C632 vo.t81 sub 0.64694f $ **FLOATING
C633 vo.n121 sub 0.272f $ **FLOATING
C634 vo.t4 sub 0.64401f $ **FLOATING
C635 vo.n122 sub 0.32952f $ **FLOATING
.ends
