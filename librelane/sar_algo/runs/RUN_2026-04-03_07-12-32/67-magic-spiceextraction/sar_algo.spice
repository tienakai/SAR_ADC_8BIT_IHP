* NGSPICE file created from sar_algo.ext - technology: ihp-sg13g2

* Black-box entry subcircuit for sg13g2_decap_8 abstract view
.subckt sg13g2_decap_8 VDD VSS
.ends

* Black-box entry subcircuit for sg13g2_fill_1 abstract view
.subckt sg13g2_fill_1 VDD VSS
.ends

* Black-box entry subcircuit for sg13g2_decap_4 abstract view
.subckt sg13g2_decap_4 VDD VSS
.ends

* Black-box entry subcircuit for sg13g2_inv_1 abstract view
.subckt sg13g2_inv_1 VDD Y A VSS
.ends

* Black-box entry subcircuit for sg13g2_nand2b_1 abstract view
.subckt sg13g2_nand2b_1 Y B A_N VDD VSS
.ends

* Black-box entry subcircuit for sg13g2_fill_2 abstract view
.subckt sg13g2_fill_2 VDD VSS
.ends

* Black-box entry subcircuit for sg13g2_a21o_1 abstract view
.subckt sg13g2_a21o_1 A2 A1 B1 X VDD VSS
.ends

* Black-box entry subcircuit for sg13g2_buf_1 abstract view
.subckt sg13g2_buf_1 A X VDD VSS
.ends

* Black-box entry subcircuit for sg13g2_xnor2_1 abstract view
.subckt sg13g2_xnor2_1 Y A B VDD VSS
.ends

* Black-box entry subcircuit for sg13g2_and2_1 abstract view
.subckt sg13g2_and2_1 A B X VDD VSS
.ends

* Black-box entry subcircuit for sg13g2_buf_16 abstract view
.subckt sg13g2_buf_16 X A VDD VSS
.ends

* Black-box entry subcircuit for sg13g2_nand4_1 abstract view
.subckt sg13g2_nand4_1 B C A Y VDD VSS D
.ends

* Black-box entry subcircuit for sg13g2_dlygate4sd3_1 abstract view
.subckt sg13g2_dlygate4sd3_1 A VDD VSS X
.ends

* Black-box entry subcircuit for sg13g2_nand3_1 abstract view
.subckt sg13g2_nand3_1 B C A Y VDD VSS
.ends

* Black-box entry subcircuit for sg13g2_dfrbpq_1 abstract view
.subckt sg13g2_dfrbpq_1 RESET_B VSS VDD D Q CLK
.ends

* Black-box entry subcircuit for sg13g2_mux2_1 abstract view
.subckt sg13g2_mux2_1 A0 A1 S X VDD VSS
.ends

* Black-box entry subcircuit for sg13g2_a21oi_1 abstract view
.subckt sg13g2_a21oi_1 VSS VDD A1 A2 Y B1
.ends

* Black-box entry subcircuit for sg13g2_nor3_1 abstract view
.subckt sg13g2_nor3_1 A B C Y VDD VSS
.ends

* Black-box entry subcircuit for sg13g2_nor2_1 abstract view
.subckt sg13g2_nor2_1 A B Y VDD VSS
.ends

* Black-box entry subcircuit for sg13g2_o21ai_1 abstract view
.subckt sg13g2_o21ai_1 B1 VDD Y VSS A1 A2
.ends

* Black-box entry subcircuit for sg13g2_a22oi_1 abstract view
.subckt sg13g2_a22oi_1 Y B1 B2 A2 A1 VDD VSS
.ends

* Black-box entry subcircuit for sg13g2_nand2_1 abstract view
.subckt sg13g2_nand2_1 Y A B VDD VSS
.ends

* Black-box entry subcircuit for sg13g2_nor2b_1 abstract view
.subckt sg13g2_nor2b_1 A B_N Y VDD VSS
.ends

* Black-box entry subcircuit for sg13g2_or2_1 abstract view
.subckt sg13g2_or2_1 VSS VDD X B A
.ends

* Black-box entry subcircuit for sg13g2_nand3b_1 abstract view
.subckt sg13g2_nand3b_1 B C Y VDD VSS A_N
.ends

* Black-box entry subcircuit for sg13g2_xor2_1 abstract view
.subckt sg13g2_xor2_1 B A X VDD VSS
.ends

.subckt sar_algo BN[0] BN[1] BN[2] BN[3] BN[4] BN[5] BN[6] B[0] B[1] B[2] B[3] B[4]
+ B[5] B[6] D[0] D[1] D[2] D[3] D[4] D[5] D[6] D[7] En Om Op VDD VSS clk_algo fclk_comp
+ fclk_in fclk_samp fdac_clk rst
XFILLER_8_170 VDD VSS sg13g2_decap_8
XFILLER_12_54 VDD VSS sg13g2_fill_1
XFILLER_12_87 VDD VSS sg13g2_decap_4
X_200_ VDD _026_ net35 VSS sg13g2_inv_1
X_131_ _082_ counter\[0\] counter\[1\] VDD VSS sg13g2_nand2b_1
XFILLER_0_79 VDD VSS sg13g2_fill_1
XFILLER_2_132 VDD VSS sg13g2_fill_2
XFILLER_9_55 VDD VSS sg13g2_fill_1
XFILLER_9_11 VDD VSS sg13g2_decap_8
X_114_ net50 net1 net48 _071_ VDD VSS sg13g2_a21o_1
XFILLER_7_268 VDD VSS sg13g2_decap_8
XFILLER_4_238 VDD VSS sg13g2_decap_8
XFILLER_3_293 VDD VSS sg13g2_decap_8
XFILLER_6_56 VDD VSS sg13g2_decap_8
XFILLER_0_274 VDD VSS sg13g2_decap_8
Xoutput20 net20 D[0] VDD VSS sg13g2_buf_1
Xoutput7 net7 BN[1] VDD VSS sg13g2_buf_1
XFILLER_10_307 VDD VSS sg13g2_fill_2
XFILLER_11_0 VDD VSS sg13g2_decap_8
XFILLER_3_35 VDD VSS sg13g2_decap_8
XFILLER_9_138 VDD VSS sg13g2_fill_1
XFILLER_9_116 VDD VSS sg13g2_decap_8
XFILLER_12_33 VDD VSS sg13g2_decap_8
XFILLER_12_66 VDD VSS sg13g2_decap_8
XFILLER_5_152 VDD VSS sg13g2_fill_1
X_130_ _058_ _081_ _079_ VDD VSS sg13g2_nand2b_1
XFILLER_0_36 VDD VSS sg13g2_fill_2
XFILLER_9_67 VDD VSS sg13g2_fill_1
X_113_ _063_ net46 _069_ VDD VSS sg13g2_xnor2_1
XFILLER_7_247 VDD VSS sg13g2_decap_8
XFILLER_7_214 VDD VSS sg13g2_decap_8
XFILLER_4_217 VDD VSS sg13g2_decap_8
XFILLER_3_272 VDD VSS sg13g2_decap_8
XFILLER_6_35 VDD VSS sg13g2_decap_8
XFILLER_0_231 VDD VSS sg13g2_decap_8
XFILLER_0_242 VDD VSS sg13g2_decap_8
Xoutput10 net10 BN[4] VDD VSS sg13g2_buf_1
Xoutput21 net21 D[1] VDD VSS sg13g2_buf_1
Xoutput8 net8 BN[2] VDD VSS sg13g2_buf_1
XFILLER_3_14 VDD VSS sg13g2_decap_8
XFILLER_10_116 VDD VSS sg13g2_fill_2
XFILLER_2_304 VDD VSS sg13g2_decap_4
XFILLER_0_15 VDD VSS sg13g2_decap_8
X_189_ VDD _015_ net38 VSS sg13g2_inv_1
XFILLER_9_46 VDD VSS sg13g2_decap_8
XFILLER_11_244 VDD VSS sg13g2_decap_8
X_112_ net44 net49 _064_ VDD VSS sg13g2_and2_1
XFILLER_1_80 VDD VSS sg13g2_fill_1
XFILLER_3_251 VDD VSS sg13g2_decap_8
XFILLER_6_14 VDD VSS sg13g2_decap_8
XFILLER_0_221 VDD VSS sg13g2_decap_4
Xoutput11 net11 BN[5] VDD VSS sg13g2_buf_1
Xoutput22 net22 D[2] VDD VSS sg13g2_buf_1
Xoutput9 net9 BN[3] VDD VSS sg13g2_buf_1
XFILLER_8_184 VDD VSS sg13g2_fill_1
XFILLER_10_128 VDD VSS sg13g2_decap_8
XFILLER_5_7 VDD VSS sg13g2_decap_8
XFILLER_5_198 VDD VSS sg13g2_decap_4
X_188_ VDD _014_ net37 VSS sg13g2_inv_1
XFILLER_9_25 VDD VSS sg13g2_decap_8
Xclkbuf_1_0__f_fclk_in clknet_1_0__leaf_fclk_in clknet_0_fclk_in VDD VSS sg13g2_buf_16
XFILLER_11_289 VDD VSS sg13g2_decap_8
X_111_ net46 net48 net1 _070_ VDD VSS cnt\[0\] sg13g2_nand4_1
XFILLER_6_282 VDD VSS sg13g2_decap_8
XFILLER_3_230 VDD VSS sg13g2_decap_8
Xhold44 cnt\[3\] VDD VSS net44 sg13g2_dlygate4sd3_1
XFILLER_0_200 VDD VSS sg13g2_decap_8
XFILLER_0_288 VDD VSS sg13g2_decap_8
Xoutput12 net12 BN[6] VDD VSS sg13g2_buf_1
Xoutput23 net23 D[3] VDD VSS sg13g2_buf_1
XFILLER_3_49 VDD VSS sg13g2_fill_2
XFILLER_5_303 VDD VSS sg13g2_decap_4
XFILLER_8_163 VDD VSS sg13g2_decap_8
XFILLER_12_47 VDD VSS sg13g2_decap_8
X_187_ VDD _013_ net37 VSS sg13g2_inv_1
XFILLER_9_291 VDD VSS sg13g2_decap_8
X_110_ net48 net50 net1 _069_ VDD VSS sg13g2_nand3_1
XFILLER_7_228 VDD VSS sg13g2_fill_2
X_239_ _033_ VSS VDD net45 net30 clknet_1_1__leaf_fclk_in_regs sg13g2_dfrbpq_1
XFILLER_6_261 VDD VSS sg13g2_decap_8
Xhold45 _000_ VDD VSS net45 sg13g2_dlygate4sd3_1
XFILLER_3_286 VDD VSS sg13g2_decap_8
XFILLER_6_49 VDD VSS sg13g2_decap_8
Xoutput13 net13 B[0] VDD VSS sg13g2_buf_1
Xoutput24 net24 D[4] VDD VSS sg13g2_buf_1
XFILLER_0_256 VDD VSS sg13g2_decap_8
XFILLER_0_267 VDD VSS sg13g2_decap_8
XFILLER_7_92 VDD VSS sg13g2_fill_2
XFILLER_7_81 VDD VSS sg13g2_decap_8
XFILLER_3_28 VDD VSS sg13g2_decap_8
XFILLER_9_109 VDD VSS sg13g2_decap_8
XFILLER_12_171 VDD VSS sg13g2_fill_1
XFILLER_12_193 VDD VSS sg13g2_decap_8
Xclkbuf_regs_0_fclk_in fclk_in_regs fclk_in VDD VSS sg13g2_buf_16
XFILLER_12_26 VDD VSS sg13g2_decap_8
XFILLER_12_59 VDD VSS sg13g2_decap_8
XFILLER_0_29 VDD VSS sg13g2_decap_8
XFILLER_2_159 VDD VSS sg13g2_fill_2
X_186_ VDD _012_ net35 VSS sg13g2_inv_1
XFILLER_1_181 VDD VSS sg13g2_fill_1
XFILLER_9_270 VDD VSS sg13g2_decap_8
XFILLER_7_207 VDD VSS sg13g2_decap_8
X_238_ _032_ VSS VDD _064_ cnt\[3\] clknet_1_1__leaf_fclk_in_regs sg13g2_dfrbpq_1
X_169_ net18 net32 _093_ _039_ VDD VSS sg13g2_mux2_1
XFILLER_6_240 VDD VSS sg13g2_decap_8
Xhold46 cnt\[2\] VDD VSS net46 sg13g2_dlygate4sd3_1
XFILLER_10_70 VDD VSS sg13g2_fill_2
XFILLER_3_265 VDD VSS sg13g2_decap_8
XFILLER_6_28 VDD VSS sg13g2_decap_8
Xoutput14 net14 B[1] VDD VSS sg13g2_buf_1
Xoutput25 net25 D[5] VDD VSS sg13g2_buf_1
XFILLER_7_60 VDD VSS sg13g2_decap_8
XFILLER_12_150 VDD VSS sg13g2_decap_8
XFILLER_8_110 VDD VSS sg13g2_decap_8
XFILLER_10_109 VDD VSS sg13g2_decap_8
XFILLER_2_308 VDD VSS sg13g2_fill_1
XFILLER_3_7 VDD VSS sg13g2_decap_8
X_185_ VDD _011_ net35 VSS sg13g2_inv_1
XFILLER_9_39 VDD VSS sg13g2_decap_8
XFILLER_1_4 VDD VSS sg13g2_decap_8
X_237_ _031_ VSS VDD net47 cnt\[2\] clknet_1_0__leaf_fclk_in_regs sg13g2_dfrbpq_1
X_168_ net19 net32 _087_ _040_ VDD VSS sg13g2_mux2_1
XFILLER_6_296 VDD VSS sg13g2_decap_8
Xhold47 _063_ VDD VSS net47 sg13g2_dlygate4sd3_1
XFILLER_3_244 VDD VSS sg13g2_decap_8
XFILLER_0_214 VDD VSS sg13g2_decap_8
XFILLER_0_225 VDD VSS sg13g2_fill_2
Xoutput15 net15 B[2] VDD VSS sg13g2_buf_1
Xoutput26 net26 D[6] VDD VSS sg13g2_buf_1
XFILLER_8_177 VDD VSS sg13g2_decap_8
XFILLER_9_18 VDD VSS sg13g2_decap_8
X_184_ VDD _010_ net34 VSS sg13g2_inv_1
X_236_ _030_ VSS VDD _062_ cnt\[1\] clknet_1_0__leaf_fclk_in_regs sg13g2_dfrbpq_1
X_167_ net20 net33 _077_ _041_ VDD VSS sg13g2_mux2_1
XFILLER_6_275 VDD VSS sg13g2_decap_8
XFILLER_3_223 VDD VSS sg13g2_decap_8
Xhold48 cnt\[1\] VDD VSS net48 sg13g2_dlygate4sd3_1
X_219_ _013_ VSS VDD _045_ net24 net42 sg13g2_dfrbpq_1
Xoutput16 net16 B[3] VDD VSS sg13g2_buf_1
Xoutput27 net27 D[7] VDD VSS sg13g2_buf_1
XFILLER_11_7 VDD VSS sg13g2_decap_8
XFILLER_8_304 VDD VSS sg13g2_decap_4
XFILLER_8_156 VDD VSS sg13g2_decap_8
XFILLER_5_307 VDD VSS sg13g2_fill_2
XFILLER_4_63 VDD VSS sg13g2_decap_4
Xfanout40 net41 net40 VDD VSS sg13g2_buf_1
X_183_ VDD _009_ net34 VSS sg13g2_inv_1
XFILLER_11_206 VDD VSS sg13g2_fill_1
XFILLER_9_284 VDD VSS sg13g2_decap_8
X_235_ _029_ VSS VDD _061_ cnt\[0\] clknet_1_0__leaf_fclk_in_regs sg13g2_dfrbpq_1
X_166_ VSS VDD _088_ _090_ _042_ _101_ sg13g2_a21oi_1
XFILLER_6_254 VDD VSS sg13g2_decap_8
XFILLER_3_202 VDD VSS sg13g2_decap_8
Xhold49 _070_ VDD VSS net49 sg13g2_dlygate4sd3_1
XFILLER_2_290 VDD VSS sg13g2_decap_8
XFILLER_3_279 VDD VSS sg13g2_decap_8
X_218_ _012_ VSS VDD _044_ net23 net41 sg13g2_dfrbpq_1
X_149_ counter\[2\] _074_ _083_ _096_ VDD VSS sg13g2_nor3_1
XFILLER_0_238 VDD VSS sg13g2_fill_1
XFILLER_0_249 VDD VSS sg13g2_decap_8
Xoutput17 net17 B[4] VDD VSS sg13g2_buf_1
Xoutput28 net28 fclk_comp VDD VSS sg13g2_buf_1
XFILLER_7_74 VDD VSS sg13g2_decap_8
XFILLER_12_164 VDD VSS sg13g2_decap_8
XFILLER_12_186 VDD VSS sg13g2_decap_8
XFILLER_12_19 VDD VSS sg13g2_decap_8
XFILLER_8_124 VDD VSS sg13g2_fill_2
XFILLER_5_105 VDD VSS sg13g2_fill_1
XFILLER_4_97 VDD VSS sg13g2_fill_2
Xfanout41 net4 net41 VDD VSS sg13g2_buf_1
X_182_ VDD _008_ net38 VSS sg13g2_inv_1
XFILLER_8_0 VDD VSS sg13g2_decap_8
XFILLER_9_263 VDD VSS sg13g2_decap_8
XFILLER_9_230 VDD VSS sg13g2_fill_1
XFILLER_1_32 VDD VSS sg13g2_decap_8
X_234_ _028_ VSS VDD _060_ _001_ clknet_1_1__leaf_fclk_in_regs sg13g2_dfrbpq_1
X_165_ net21 _088_ _101_ VDD VSS sg13g2_nor2_1
XFILLER_6_233 VDD VSS sg13g2_decap_8
XFILLER_10_63 VDD VSS sg13g2_decap_8
XFILLER_3_258 VDD VSS sg13g2_decap_8
X_217_ _011_ VSS VDD _043_ net22 net40 sg13g2_dfrbpq_1
X_148_ _095_ VDD _054_ VSS _068_ _093_ sg13g2_o21ai_1
Xoutput18 net18 B[5] VDD VSS sg13g2_buf_1
Xoutput29 net29 fclk_samp VDD VSS sg13g2_buf_1
XFILLER_7_53 VDD VSS sg13g2_fill_2
XFILLER_8_103 VDD VSS sg13g2_decap_8
XFILLER_4_32 VDD VSS sg13g2_decap_8
Xfanout31 _074_ net31 VDD VSS sg13g2_buf_1
Xfanout42 net4 net42 VDD VSS sg13g2_buf_1
X_181_ VDD _007_ net38 VSS sg13g2_inv_1
XFILLER_1_153 VDD VSS sg13g2_fill_1
XFILLER_9_242 VDD VSS sg13g2_decap_8
XFILLER_10_296 VDD VSS sg13g2_decap_8
XFILLER_1_11 VDD VSS sg13g2_decap_8
X_233_ _027_ VSS VDD _059_ counter\[3\] net41 sg13g2_dfrbpq_1
X_164_ net22 net33 _099_ _043_ VDD VSS sg13g2_mux2_1
XFILLER_6_289 VDD VSS sg13g2_decap_8
XFILLER_10_42 VDD VSS sg13g2_decap_8
XFILLER_3_237 VDD VSS sg13g2_decap_8
X_216_ _010_ VSS VDD _042_ net21 net40 sg13g2_dfrbpq_1
X_147_ _094_ VDD _095_ VSS _086_ _088_ sg13g2_o21ai_1
XFILLER_0_207 VDD VSS sg13g2_decap_8
Xoutput19 net19 B[6] VDD VSS sg13g2_buf_1
XFILLER_7_32 VDD VSS sg13g2_decap_8
XFILLER_12_122 VDD VSS sg13g2_decap_8
XFILLER_12_133 VDD VSS sg13g2_fill_2
XFILLER_8_126 VDD VSS sg13g2_fill_1
XFILLER_4_11 VDD VSS sg13g2_decap_8
Xfanout32 net33 net32 VDD VSS sg13g2_buf_1
Xfanout43 net4 net43 VDD VSS sg13g2_buf_1
X_180_ VDD _006_ net38 VSS sg13g2_inv_1
XFILLER_9_298 VDD VSS sg13g2_decap_8
X_232_ _026_ VSS VDD _058_ counter\[2\] net41 sg13g2_dfrbpq_1
X_163_ net23 net33 _098_ _044_ VDD VSS sg13g2_mux2_1
XFILLER_6_268 VDD VSS sg13g2_decap_8
XFILLER_10_21 VDD VSS sg13g2_decap_8
XFILLER_3_216 VDD VSS sg13g2_decap_8
X_215_ _009_ VSS VDD _041_ net20 net40 sg13g2_dfrbpq_1
X_146_ _082_ net33 _094_ VDD VSS sg13g2_nor2_1
XFILLER_8_308 VDD VSS sg13g2_fill_1
XFILLER_7_88 VDD VSS sg13g2_decap_4
XFILLER_7_11 VDD VSS sg13g2_decap_8
X_129_ _081_ _080_ counter\[2\] _075_ _073_ VDD VSS sg13g2_a22oi_1
XFILLER_7_193 VDD VSS sg13g2_decap_8
XFILLER_1_303 VDD VSS sg13g2_fill_2
Xfanout33 _089_ net33 VDD VSS sg13g2_buf_1
XFILLER_9_277 VDD VSS sg13g2_decap_8
X_231_ _025_ VSS VDD _057_ counter\[1\] net41 sg13g2_dfrbpq_1
X_162_ VSS VDD _079_ _090_ _045_ _100_ sg13g2_a21oi_1
XFILLER_6_247 VDD VSS sg13g2_decap_8
XFILLER_6_0 VDD VSS sg13g2_decap_8
Xinput1 En net1 VDD VSS sg13g2_buf_1
XFILLER_2_250 VDD VSS sg13g2_fill_1
XFILLER_2_283 VDD VSS sg13g2_decap_8
X_214_ _008_ VSS VDD _040_ net19 net43 sg13g2_dfrbpq_1
X_145_ counter\[2\] net31 _082_ _093_ VDD VSS sg13g2_nor3_1
X_128_ net1 VDD _080_ VSS net29 _065_ sg13g2_o21ai_1
XFILLER_7_67 VDD VSS sg13g2_decap_8
XFILLER_12_146 VDD VSS sg13g2_fill_1
XFILLER_12_157 VDD VSS sg13g2_decap_8
XFILLER_12_179 VDD VSS sg13g2_decap_8
XFILLER_8_117 VDD VSS sg13g2_decap_8
XFILLER_4_301 VDD VSS sg13g2_decap_4
XFILLER_4_46 VDD VSS sg13g2_decap_8
Xfanout34 net35 net34 VDD VSS sg13g2_buf_1
XFILLER_9_256 VDD VSS sg13g2_decap_8
XFILLER_10_222 VDD VSS sg13g2_fill_2
XFILLER_10_255 VDD VSS sg13g2_decap_4
X_230_ _024_ VSS VDD _056_ counter\[0\] net41 sg13g2_dfrbpq_1
X_161_ net24 _079_ _100_ VDD VSS sg13g2_nor2_1
XFILLER_6_226 VDD VSS sg13g2_decap_8
XFILLER_1_25 VDD VSS sg13g2_decap_8
XFILLER_10_56 VDD VSS sg13g2_decap_8
Xinput2 Om net2 VDD VSS sg13g2_buf_1
XFILLER_2_262 VDD VSS sg13g2_decap_8
X_213_ _007_ VSS VDD _039_ net18 net43 sg13g2_dfrbpq_1
X_144_ _092_ VDD _055_ VSS _067_ _087_ sg13g2_o21ai_1
X_127_ counter\[2\] _073_ net31 _079_ VDD VSS sg13g2_nor3_1
XFILLER_7_46 VDD VSS sg13g2_decap_8
XFILLER_12_114 VDD VSS sg13g2_decap_4
XFILLER_4_25 VDD VSS sg13g2_decap_8
Xfanout35 net39 net35 VDD VSS sg13g2_buf_1
XFILLER_9_235 VDD VSS sg13g2_decap_8
XFILLER_8_290 VDD VSS sg13g2_decap_8
XFILLER_10_289 VDD VSS sg13g2_decap_8
X_160_ net25 net32 _096_ _046_ VDD VSS sg13g2_mux2_1
Xinput3 Op net3 VDD VSS sg13g2_buf_1
XFILLER_5_282 VDD VSS sg13g2_decap_8
XFILLER_10_35 VDD VSS sg13g2_decap_8
X_212_ _006_ VSS VDD _038_ net17 net42 sg13g2_dfrbpq_1
X_143_ _091_ VDD _092_ VSS _086_ _088_ sg13g2_o21ai_1
XFILLER_2_80 VDD VSS sg13g2_fill_2
X_126_ _078_ counter\[3\] _077_ _059_ VDD VSS sg13g2_a21o_1
XFILLER_7_25 VDD VSS sg13g2_decap_8
X_109_ VDD _002_ net37 VSS sg13g2_inv_1
XFILLER_4_166 VDD VSS sg13g2_fill_2
Xfanout36 net39 net36 VDD VSS sg13g2_buf_1
XFILLER_9_214 VDD VSS sg13g2_decap_4
XFILLER_5_91 VDD VSS sg13g2_decap_8
XFILLER_10_224 VDD VSS sg13g2_fill_1
Xinput4 clk_algo net4 VDD VSS sg13g2_buf_1
XFILLER_5_261 VDD VSS sg13g2_decap_8
XFILLER_10_14 VDD VSS sg13g2_decap_8
XFILLER_3_209 VDD VSS sg13g2_decap_8
X_211_ _005_ VSS VDD _037_ net16 net42 sg13g2_dfrbpq_1
X_142_ counter\[1\] counter\[0\] net32 _091_ VDD VSS sg13g2_nor3_1
XFILLER_2_297 VDD VSS sg13g2_decap_8
X_125_ _078_ net1 net29 VDD VSS sg13g2_nand2_1
XFILLER_11_171 VDD VSS sg13g2_fill_1
X_108_ VDD _068_ net11 VSS sg13g2_inv_1
XFILLER_7_153 VDD VSS sg13g2_fill_1
Xfanout37 net39 net37 VDD VSS sg13g2_buf_1
XFILLER_8_7 VDD VSS sg13g2_decap_8
XFILLER_5_70 VDD VSS sg13g2_decap_8
XFILLER_1_39 VDD VSS sg13g2_decap_8
Xinput5 rst net5 VDD VSS sg13g2_buf_1
XFILLER_5_240 VDD VSS sg13g2_decap_8
XFILLER_2_232 VDD VSS sg13g2_decap_8
XFILLER_2_276 VDD VSS sg13g2_decap_8
X_210_ _004_ VSS VDD _036_ net15 net42 sg13g2_dfrbpq_1
X_141_ _090_ net3 net2 VDD VSS sg13g2_nand2b_1
XFILLER_2_82 VDD VSS sg13g2_fill_1
X_124_ _073_ _076_ _077_ VDD VSS sg13g2_nor2_1
XFILLER_12_139 VDD VSS sg13g2_decap_8
X_107_ VDD _067_ net12 VSS sg13g2_inv_1
XFILLER_4_39 VDD VSS sg13g2_decap_8
XFILLER_3_190 VDD VSS sg13g2_fill_2
Xfanout38 net39 net38 VDD VSS sg13g2_buf_1
XFILLER_9_249 VDD VSS sg13g2_decap_8
XFILLER_0_182 VDD VSS sg13g2_decap_8
XFILLER_1_18 VDD VSS sg13g2_decap_8
XFILLER_5_296 VDD VSS sg13g2_decap_8
XFILLER_10_49 VDD VSS sg13g2_decap_8
XFILLER_2_211 VDD VSS sg13g2_decap_8
XFILLER_2_255 VDD VSS sg13g2_decap_8
X_140_ net2 net3 _089_ VDD VSS sg13g2_nor2b_1
XFILLER_2_94 VDD VSS sg13g2_fill_2
XFILLER_11_70 VDD VSS sg13g2_decap_4
X_123_ VSS VDD _076_ net31 _066_ sg13g2_or2_1
XFILLER_7_39 VDD VSS sg13g2_decap_8
XFILLER_7_303 VDD VSS sg13g2_fill_2
XFILLER_12_107 VDD VSS sg13g2_decap_8
XFILLER_12_118 VDD VSS sg13g2_fill_1
XFILLER_12_129 VDD VSS sg13g2_decap_4
X_106_ VDD _066_ counter\[2\] VSS sg13g2_inv_1
XFILLER_7_144 VDD VSS sg13g2_fill_2
XFILLER_4_18 VDD VSS sg13g2_decap_8
Xclkbuf_1_0__f_fclk_in_regs clknet_1_0__leaf_fclk_in_regs clknet_0_fclk_in_regs VDD
+ VSS sg13g2_buf_16
Xfanout39 net5 net39 VDD VSS sg13g2_buf_1
XFILLER_9_228 VDD VSS sg13g2_fill_2
XFILLER_8_283 VDD VSS sg13g2_decap_8
XFILLER_10_28 VDD VSS sg13g2_decap_8
XFILLER_5_275 VDD VSS sg13g2_decap_8
X_199_ VDD _025_ net37 VSS sg13g2_inv_1
XFILLER_2_0 VDD VSS sg13g2_decap_8
X_122_ _066_ net31 _075_ VDD VSS sg13g2_nor2_1
XFILLER_7_18 VDD VSS sg13g2_decap_8
X_105_ VDD _065_ counter\[3\] VSS sg13g2_inv_1
XFILLER_8_94 VDD VSS sg13g2_decap_4
XFILLER_9_207 VDD VSS sg13g2_decap_8
XFILLER_8_262 VDD VSS sg13g2_decap_8
XFILLER_6_7 VDD VSS sg13g2_decap_8
XFILLER_5_254 VDD VSS sg13g2_decap_8
XFILLER_2_246 VDD VSS sg13g2_decap_4
X_198_ VDD _024_ net35 VSS sg13g2_inv_1
XFILLER_4_4 VDD VSS sg13g2_decap_8
X_121_ _001_ net1 _074_ VDD VSS counter\[3\] sg13g2_nand3b_1
X_104_ VDD net29 net51 VSS sg13g2_inv_1
XFILLER_10_0 VDD VSS sg13g2_decap_8
XFILLER_12_281 VDD VSS sg13g2_decap_8
XFILLER_5_63 VDD VSS sg13g2_decap_8
XFILLER_5_233 VDD VSS sg13g2_decap_8
XFILLER_2_225 VDD VSS sg13g2_decap_8
XFILLER_2_269 VDD VSS sg13g2_decap_8
X_197_ VDD _023_ net37 VSS sg13g2_inv_1
XFILLER_2_42 VDD VSS sg13g2_decap_8
X_120_ _073_ counter\[1\] counter\[0\] VDD VSS sg13g2_nand2_1
XFILLER_8_297 VDD VSS sg13g2_decap_8
XFILLER_5_42 VDD VSS sg13g2_decap_8
XFILLER_5_289 VDD VSS sg13g2_decap_8
XFILLER_5_212 VDD VSS sg13g2_decap_8
XFILLER_2_204 VDD VSS sg13g2_decap_8
XFILLER_1_292 VDD VSS sg13g2_decap_8
XFILLER_2_21 VDD VSS sg13g2_decap_8
X_196_ VDD _022_ net35 VSS sg13g2_inv_1
XFILLER_11_303 VDD VSS sg13g2_decap_4
XFILLER_11_63 VDD VSS sg13g2_decap_8
X_179_ VDD _005_ net37 VSS sg13g2_inv_1
XFILLER_11_199 VDD VSS sg13g2_decap_8
XFILLER_7_126 VDD VSS sg13g2_fill_2
XFILLER_8_86 VDD VSS sg13g2_fill_2
XFILLER_8_42 VDD VSS sg13g2_decap_8
XFILLER_3_195 VDD VSS sg13g2_decap_8
XFILLER_0_110 VDD VSS sg13g2_decap_4
XFILLER_8_276 VDD VSS sg13g2_decap_8
XFILLER_5_21 VDD VSS sg13g2_decap_8
XFILLER_5_98 VDD VSS sg13g2_decap_8
XFILLER_5_268 VDD VSS sg13g2_decap_8
XFILLER_1_271 VDD VSS sg13g2_decap_8
Xclkbuf_0_fclk_in_regs clknet_0_fclk_in_regs fclk_in_regs VDD VSS sg13g2_buf_16
X_195_ VDD _021_ net35 VSS sg13g2_inv_1
XFILLER_11_42 VDD VSS sg13g2_decap_8
X_178_ VDD _004_ net37 VSS sg13g2_inv_1
XFILLER_3_300 VDD VSS sg13g2_decap_8
XFILLER_8_98 VDD VSS sg13g2_fill_2
XFILLER_8_21 VDD VSS sg13g2_decap_8
XFILLER_6_171 VDD VSS sg13g2_decap_8
XFILLER_6_160 VDD VSS sg13g2_decap_8
XFILLER_0_303 VDD VSS sg13g2_fill_2
XFILLER_3_185 VDD VSS sg13g2_fill_1
XFILLER_8_255 VDD VSS sg13g2_decap_8
XFILLER_5_77 VDD VSS sg13g2_decap_4
XFILLER_5_247 VDD VSS sg13g2_decap_8
XFILLER_4_280 VDD VSS sg13g2_decap_8
XFILLER_2_239 VDD VSS sg13g2_decap_8
X_194_ VDD _020_ net34 VSS sg13g2_inv_1
XFILLER_11_21 VDD VSS sg13g2_decap_8
Xclkbuf_0_fclk_in clknet_0_fclk_in fclk_in VDD VSS sg13g2_buf_16
X_177_ VDD _003_ net37 VSS sg13g2_inv_1
XFILLER_9_191 VDD VSS sg13g2_decap_4
XFILLER_7_128 VDD VSS sg13g2_fill_1
X_229_ _023_ VSS VDD _055_ net12 net42 sg13g2_dfrbpq_1
XFILLER_8_88 VDD VSS sg13g2_fill_1
XFILLER_0_123 VDD VSS sg13g2_fill_2
XFILLER_0_189 VDD VSS sg13g2_fill_2
XFILLER_12_230 VDD VSS sg13g2_fill_1
XFILLER_12_274 VDD VSS sg13g2_decap_8
XFILLER_5_56 VDD VSS sg13g2_decap_8
XFILLER_5_226 VDD VSS sg13g2_decap_8
XFILLER_2_218 VDD VSS sg13g2_decap_8
X_193_ VDD _019_ net34 VSS sg13g2_inv_1
XFILLER_2_35 VDD VSS sg13g2_decap_8
XFILLER_11_77 VDD VSS sg13g2_fill_2
X_176_ VSS VDD _088_ _090_ _034_ _103_ sg13g2_a21oi_1
Xclkbuf_1_1__f_fclk_in_regs clknet_1_1__leaf_fclk_in_regs clknet_0_fclk_in_regs VDD
+ VSS sg13g2_buf_16
X_228_ _022_ VSS VDD _054_ net11 net41 sg13g2_dfrbpq_1
X_159_ net26 net32 _093_ _047_ VDD VSS sg13g2_mux2_1
XFILLER_12_8 VDD VSS sg13g2_decap_8
XFILLER_12_242 VDD VSS sg13g2_decap_8
XFILLER_5_35 VDD VSS sg13g2_decap_8
XFILLER_5_205 VDD VSS sg13g2_decap_8
X_192_ VDD _018_ net34 VSS sg13g2_inv_1
XFILLER_1_285 VDD VSS sg13g2_decap_8
XFILLER_2_14 VDD VSS sg13g2_decap_8
XFILLER_11_307 VDD VSS sg13g2_fill_2
XFILLER_11_56 VDD VSS sg13g2_decap_8
XFILLER_2_7 VDD VSS sg13g2_decap_8
X_175_ net13 _088_ _103_ VDD VSS sg13g2_nor2_1
XFILLER_9_160 VDD VSS sg13g2_decap_8
XFILLER_0_4 VDD VSS sg13g2_decap_8
XFILLER_10_181 VDD VSS sg13g2_decap_8
X_227_ _021_ VSS VDD _053_ net10 net40 sg13g2_dfrbpq_1
X_158_ net27 net32 _087_ _048_ VDD VSS sg13g2_mux2_1
XFILLER_8_79 VDD VSS sg13g2_decap_8
XFILLER_8_35 VDD VSS sg13g2_decap_8
XFILLER_6_185 VDD VSS sg13g2_decap_4
XFILLER_8_269 VDD VSS sg13g2_decap_8
XFILLER_5_14 VDD VSS sg13g2_decap_8
XFILLER_4_294 VDD VSS sg13g2_decap_8
XFILLER_1_264 VDD VSS sg13g2_decap_8
X_191_ VDD _017_ net34 VSS sg13g2_inv_1
XFILLER_11_35 VDD VSS sg13g2_decap_8
XFILLER_11_79 VDD VSS sg13g2_fill_1
X_174_ net14 net33 _099_ _035_ VDD VSS sg13g2_mux2_1
XFILLER_3_91 VDD VSS sg13g2_fill_2
X_226_ _020_ VSS VDD _052_ net9 net40 sg13g2_dfrbpq_1
X_157_ net6 _090_ _088_ _049_ VDD VSS sg13g2_mux2_1
XFILLER_8_14 VDD VSS sg13g2_decap_8
XFILLER_6_153 VDD VSS sg13g2_decap_8
XFILLER_6_142 VDD VSS sg13g2_decap_8
XFILLER_3_178 VDD VSS sg13g2_decap_8
X_209_ _003_ VSS VDD _035_ net14 net42 sg13g2_dfrbpq_1
XFILLER_12_200 VDD VSS sg13g2_decap_8
XFILLER_12_288 VDD VSS sg13g2_decap_8
XFILLER_12_299 VDD VSS sg13g2_fill_2
XFILLER_8_215 VDD VSS sg13g2_fill_2
XFILLER_10_7 VDD VSS sg13g2_decap_8
XFILLER_4_273 VDD VSS sg13g2_decap_8
XFILLER_2_49 VDD VSS sg13g2_fill_1
X_190_ VDD _016_ net38 VSS sg13g2_inv_1
XFILLER_11_14 VDD VSS sg13g2_decap_8
X_173_ net15 net32 _098_ _036_ VDD VSS sg13g2_mux2_1
XFILLER_9_195 VDD VSS sg13g2_fill_2
XFILLER_9_184 VDD VSS sg13g2_decap_8
X_225_ _019_ VSS VDD _051_ net8 net40 sg13g2_dfrbpq_1
X_156_ net7 _090_ _099_ _050_ VDD VSS sg13g2_mux2_1
X_208_ _002_ VSS VDD _034_ net13 net42 sg13g2_dfrbpq_1
X_139_ _066_ net31 _083_ _088_ VDD VSS sg13g2_nor3_1
XFILLER_12_267 VDD VSS sg13g2_decap_8
XFILLER_5_49 VDD VSS sg13g2_decap_8
XFILLER_7_282 VDD VSS sg13g2_decap_8
XFILLER_5_219 VDD VSS sg13g2_decap_8
XFILLER_4_252 VDD VSS sg13g2_decap_8
XFILLER_6_70 VDD VSS sg13g2_decap_4
XFILLER_1_299 VDD VSS sg13g2_decap_4
XFILLER_2_28 VDD VSS sg13g2_decap_8
X_172_ VSS VDD _079_ _090_ _037_ _102_ sg13g2_a21oi_1
XFILLER_9_130 VDD VSS sg13g2_fill_2
XFILLER_6_303 VDD VSS sg13g2_decap_4
XFILLER_12_80 VDD VSS sg13g2_decap_8
XFILLER_12_91 VDD VSS sg13g2_fill_2
X_224_ _018_ VSS VDD _050_ net7 net40 sg13g2_dfrbpq_1
X_155_ _076_ _082_ _099_ VDD VSS sg13g2_nor2_1
XFILLER_6_111 VDD VSS sg13g2_fill_2
X_207_ VDD _033_ net36 VSS sg13g2_inv_1
X_138_ counter\[0\] _086_ _087_ VDD VSS sg13g2_nor2b_1
XFILLER_12_235 VDD VSS sg13g2_decap_8
XFILLER_8_217 VDD VSS sg13g2_fill_1
XFILLER_5_28 VDD VSS sg13g2_decap_8
XFILLER_7_261 VDD VSS sg13g2_decap_8
XFILLER_4_231 VDD VSS sg13g2_decap_8
XFILLER_9_4 VDD VSS sg13g2_decap_8
XFILLER_1_278 VDD VSS sg13g2_decap_8
XFILLER_11_49 VDD VSS sg13g2_decap_8
X_240_ clknet_1_0__leaf_fclk_in net28 VDD VSS sg13g2_buf_1
X_171_ net16 _079_ _102_ VDD VSS sg13g2_nor2_1
XFILLER_9_153 VDD VSS sg13g2_decap_8
XFILLER_3_307 VDD VSS sg13g2_fill_2
X_223_ _017_ VSS VDD _049_ net6 net40 sg13g2_dfrbpq_1
XFILLER_8_28 VDD VSS sg13g2_decap_8
X_154_ net8 _090_ _098_ _051_ VDD VSS sg13g2_mux2_1
XFILLER_6_189 VDD VSS sg13g2_fill_1
XFILLER_6_178 VDD VSS sg13g2_decap_8
XFILLER_2_170 VDD VSS sg13g2_fill_1
X_206_ VDD _032_ net36 VSS sg13g2_inv_1
X_137_ counter\[2\] counter\[1\] net31 _086_ VDD VSS sg13g2_nor3_1
XFILLER_9_60 VDD VSS sg13g2_decap_8
XFILLER_12_214 VDD VSS sg13g2_fill_1
XFILLER_7_240 VDD VSS sg13g2_decap_8
XFILLER_4_287 VDD VSS sg13g2_decap_8
XFILLER_11_28 VDD VSS sg13g2_decap_8
X_170_ net17 net32 _096_ _038_ VDD VSS sg13g2_mux2_1
XFILLER_3_51 VDD VSS sg13g2_fill_1
XFILLER_9_132 VDD VSS sg13g2_fill_1
XFILLER_10_142 VDD VSS sg13g2_fill_2
XFILLER_10_164 VDD VSS sg13g2_decap_4
X_222_ _016_ VSS VDD _048_ net27 net43 sg13g2_dfrbpq_1
X_153_ counter\[1\] counter\[0\] _076_ _098_ VDD VSS sg13g2_nor3_1
XFILLER_6_113 VDD VSS sg13g2_fill_1
X_205_ VDD _031_ net36 VSS sg13g2_inv_1
X_136_ _085_ VDD _056_ VSS counter\[0\] net31 sg13g2_o21ai_1
XFILLER_12_226 VDD VSS sg13g2_decap_4
X_119_ net45 _072_ _060_ VDD VSS sg13g2_nor2b_1
XFILLER_7_296 VDD VSS sg13g2_decap_8
XFILLER_4_266 VDD VSS sg13g2_decap_8
XFILLER_1_225 VDD VSS sg13g2_fill_2
XFILLER_9_177 VDD VSS sg13g2_decap_8
X_221_ _015_ VSS VDD _047_ net26 net43 sg13g2_dfrbpq_1
X_152_ net9 _090_ _079_ _052_ VDD VSS sg13g2_mux2_1
XFILLER_5_0 VDD VSS sg13g2_decap_8
XFILLER_5_191 VDD VSS sg13g2_decap_8
XFILLER_5_180 VDD VSS sg13g2_decap_8
X_204_ VDD _030_ net34 VSS sg13g2_inv_1
X_135_ _085_ counter\[0\] _080_ VDD VSS sg13g2_nand2_1
XFILLER_12_249 VDD VSS sg13g2_fill_1
X_118_ net29 VDD _072_ VSS net44 net49 sg13g2_o21ai_1
XFILLER_7_275 VDD VSS sg13g2_decap_8
XFILLER_4_245 VDD VSS sg13g2_decap_8
XFILLER_6_63 VDD VSS sg13g2_decap_8
XFILLER_0_281 VDD VSS sg13g2_decap_8
XFILLER_10_303 VDD VSS sg13g2_decap_4
XFILLER_6_307 VDD VSS sg13g2_fill_2
XFILLER_9_123 VDD VSS sg13g2_decap_8
XFILLER_7_4 VDD VSS sg13g2_decap_8
XFILLER_3_42 VDD VSS sg13g2_decap_8
XFILLER_10_188 VDD VSS sg13g2_fill_1
XFILLER_12_40 VDD VSS sg13g2_decap_8
XFILLER_12_73 VDD VSS sg13g2_decap_8
X_220_ _014_ VSS VDD _046_ net25 net42 sg13g2_dfrbpq_1
X_151_ VSS VDD net33 _096_ _053_ _097_ sg13g2_a21oi_1
XFILLER_6_104 VDD VSS sg13g2_decap_8
X_203_ VDD _029_ net34 VSS sg13g2_inv_1
X_134_ _080_ counter\[1\] _084_ _057_ VDD VSS sg13g2_a21o_1
X_117_ net44 net29 _070_ _000_ VDD VSS sg13g2_nor3_1
XFILLER_7_254 VDD VSS sg13g2_decap_8
XFILLER_7_221 VDD VSS sg13g2_decap_8
XFILLER_4_224 VDD VSS sg13g2_decap_8
XFILLER_6_42 VDD VSS sg13g2_decap_8
XFILLER_9_102 VDD VSS sg13g2_decap_8
XFILLER_3_21 VDD VSS sg13g2_decap_8
XFILLER_3_87 VDD VSS sg13g2_decap_4
X_150_ net10 _096_ _097_ VDD VSS sg13g2_nor2_1
XFILLER_0_22 VDD VSS sg13g2_decap_8
X_202_ VDD _028_ net36 VSS sg13g2_inv_1
X_133_ VSS VDD _082_ _083_ _084_ net31 sg13g2_a21oi_1
XFILLER_0_77 VDD VSS sg13g2_fill_2
XFILLER_9_53 VDD VSS sg13g2_fill_2
XFILLER_12_207 VDD VSS sg13g2_decap_8
XFILLER_11_251 VDD VSS sg13g2_fill_1
X_116_ net50 net1 _061_ VDD VSS sg13g2_xor2_1
XFILLER_7_233 VDD VSS sg13g2_decap_8
XFILLER_7_200 VDD VSS sg13g2_decap_8
Xhold50 cnt\[0\] VDD VSS net50 sg13g2_dlygate4sd3_1
XFILLER_6_21 VDD VSS sg13g2_decap_8
XFILLER_9_136 VDD VSS sg13g2_fill_2
XFILLER_10_102 VDD VSS sg13g2_decap_8
XFILLER_10_135 VDD VSS sg13g2_decap_8
XFILLER_10_157 VDD VSS sg13g2_decap_8
XFILLER_6_117 VDD VSS sg13g2_decap_8
XFILLER_3_0 VDD VSS sg13g2_decap_8
X_201_ VDD _027_ net35 VSS sg13g2_inv_1
X_132_ _083_ counter\[1\] counter\[0\] VDD VSS sg13g2_nand2b_1
XFILLER_9_32 VDD VSS sg13g2_decap_8
XFILLER_12_219 VDD VSS sg13g2_decap_8
XFILLER_11_296 VDD VSS sg13g2_decap_8
X_115_ _069_ _071_ _062_ VDD VSS sg13g2_and2_1
XFILLER_7_289 VDD VSS sg13g2_decap_8
Xhold51 _001_ VDD VSS net51 sg13g2_dlygate4sd3_1
XFILLER_4_259 VDD VSS sg13g2_decap_8
XFILLER_1_218 VDD VSS sg13g2_decap_8
Xoutput30 net30 fdac_clk VDD VSS sg13g2_buf_1
Xoutput6 net6 BN[0] VDD VSS sg13g2_buf_1
XFILLER_0_295 VDD VSS sg13g2_decap_4
.ends
